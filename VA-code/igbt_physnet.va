`include "disciplines.vams"

module igbt_physnet (a, g, c);
    inout a, g, c;
    electrical a, g, c;

    // Configuration parameters
    parameter integer input_size = 3;      // Vgs, Vds, Tj
    parameter integer hidden1_size = 32;
    parameter integer hidden2_size = 64;
    parameter integer output_size = 1;     // Id
    parameter real alpha = 1/0.08903395398803755;
    parameter real beta = 1;
    parameter real epsilon = 1e-6;
    parameter real Vce_max = 1200;
    parameter real Vge_th = 5.0;
    parameter real Vge_max = 20.0;
    parameter real Ic_leak = 1e-6;
    parameter real Ic_max = 200.0;

    // State variables
    integer weights_loaded;

    // Input/output variables
    real vge, vce, Tj, Id_predicted;

    // Unrolled weights and biases for hidden1 (3*32)
    real inputs_0; real inputs_1; real inputs_2;
    real input_mean_0; real input_mean_1; real input_mean_2;
    real input_std_0; real input_std_1; real input_std_2;
    real output_mean;
    real output_std;
    real weights_h1_0; real weights_h1_1; real weights_h1_2; real weights_h1_3; real weights_h1_4; real weights_h1_5; real weights_h1_6; real weights_h1_7; real weights_h1_8; real weights_h1_9;
    real weights_h1_10; real weights_h1_11; real weights_h1_12; real weights_h1_13; real weights_h1_14; real weights_h1_15; real weights_h1_16; real weights_h1_17; real weights_h1_18; real weights_h1_19;
    real weights_h1_20; real weights_h1_21; real weights_h1_22; real weights_h1_23; real weights_h1_24; real weights_h1_25; real weights_h1_26; real weights_h1_27; real weights_h1_28; real weights_h1_29;
    real weights_h1_30; real weights_h1_31; real weights_h1_32; real weights_h1_33; real weights_h1_34; real weights_h1_35; real weights_h1_36; real weights_h1_37; real weights_h1_38; real weights_h1_39;
    real weights_h1_40; real weights_h1_41; real weights_h1_42; real weights_h1_43; real weights_h1_44; real weights_h1_45; real weights_h1_46; real weights_h1_47; real weights_h1_48; real weights_h1_49;
    real weights_h1_50; real weights_h1_51; real weights_h1_52; real weights_h1_53; real weights_h1_54; real weights_h1_55; real weights_h1_56; real weights_h1_57; real weights_h1_58; real weights_h1_59;
    real weights_h1_60; real weights_h1_61; real weights_h1_62; real weights_h1_63; real weights_h1_64; real weights_h1_65; real weights_h1_66; real weights_h1_67; real weights_h1_68; real weights_h1_69;
    real weights_h1_70; real weights_h1_71; real weights_h1_72; real weights_h1_73; real weights_h1_74; real weights_h1_75; real weights_h1_76; real weights_h1_77; real weights_h1_78; real weights_h1_79;
    real weights_h1_80; real weights_h1_81; real weights_h1_82; real weights_h1_83; real weights_h1_84; real weights_h1_85; real weights_h1_86; real weights_h1_87; real weights_h1_88; real weights_h1_89;
    real weights_h1_90; real weights_h1_91; real weights_h1_92; real weights_h1_93; real weights_h1_94; real weights_h1_95;
    real bias_h1_0; real bias_h1_1; real bias_h1_2; real bias_h1_3; real bias_h1_4; real bias_h1_5; real bias_h1_6; real bias_h1_7; real bias_h1_8; real bias_h1_9;
    real bias_h1_10; real bias_h1_11; real bias_h1_12; real bias_h1_13; real bias_h1_14; real bias_h1_15; real bias_h1_16; real bias_h1_17; real bias_h1_18; real bias_h1_19;
    real bias_h1_20; real bias_h1_21; real bias_h1_22; real bias_h1_23; real bias_h1_24; real bias_h1_25; real bias_h1_26; real bias_h1_27; real bias_h1_28; real bias_h1_29;
    real bias_h1_30; real bias_h1_31;
    real weights_h2_0; real weights_h2_1; real weights_h2_2; real weights_h2_3; real weights_h2_4; real weights_h2_5; real weights_h2_6; real weights_h2_7; real weights_h2_8; real weights_h2_9;
    real weights_h2_10; real weights_h2_11; real weights_h2_12; real weights_h2_13; real weights_h2_14; real weights_h2_15; real weights_h2_16; real weights_h2_17; real weights_h2_18; real weights_h2_19;
    real weights_h2_20; real weights_h2_21; real weights_h2_22; real weights_h2_23; real weights_h2_24; real weights_h2_25; real weights_h2_26; real weights_h2_27; real weights_h2_28; real weights_h2_29;
    real weights_h2_30; real weights_h2_31; real weights_h2_32; real weights_h2_33; real weights_h2_34; real weights_h2_35; real weights_h2_36; real weights_h2_37; real weights_h2_38; real weights_h2_39;
    real weights_h2_40; real weights_h2_41; real weights_h2_42; real weights_h2_43; real weights_h2_44; real weights_h2_45; real weights_h2_46; real weights_h2_47; real weights_h2_48; real weights_h2_49;
    real weights_h2_50; real weights_h2_51; real weights_h2_52; real weights_h2_53; real weights_h2_54; real weights_h2_55; real weights_h2_56; real weights_h2_57; real weights_h2_58; real weights_h2_59;
    real weights_h2_60; real weights_h2_61; real weights_h2_62; real weights_h2_63; real weights_h2_64; real weights_h2_65; real weights_h2_66; real weights_h2_67; real weights_h2_68; real weights_h2_69;
    real weights_h2_70; real weights_h2_71; real weights_h2_72; real weights_h2_73; real weights_h2_74; real weights_h2_75; real weights_h2_76; real weights_h2_77; real weights_h2_78; real weights_h2_79;
    real weights_h2_80; real weights_h2_81; real weights_h2_82; real weights_h2_83; real weights_h2_84; real weights_h2_85; real weights_h2_86; real weights_h2_87; real weights_h2_88; real weights_h2_89;
    real weights_h2_90; real weights_h2_91; real weights_h2_92; real weights_h2_93; real weights_h2_94; real weights_h2_95; real weights_h2_96; real weights_h2_97; real weights_h2_98; real weights_h2_99;
    real weights_h2_100; real weights_h2_101; real weights_h2_102; real weights_h2_103; real weights_h2_104; real weights_h2_105; real weights_h2_106; real weights_h2_107; real weights_h2_108; real weights_h2_109;
    real weights_h2_110; real weights_h2_111; real weights_h2_112; real weights_h2_113; real weights_h2_114; real weights_h2_115; real weights_h2_116; real weights_h2_117; real weights_h2_118; real weights_h2_119;
    real weights_h2_120; real weights_h2_121; real weights_h2_122; real weights_h2_123; real weights_h2_124; real weights_h2_125; real weights_h2_126; real weights_h2_127; real weights_h2_128; real weights_h2_129;
    real weights_h2_130; real weights_h2_131; real weights_h2_132; real weights_h2_133; real weights_h2_134; real weights_h2_135; real weights_h2_136; real weights_h2_137; real weights_h2_138; real weights_h2_139;
    real weights_h2_140; real weights_h2_141; real weights_h2_142; real weights_h2_143; real weights_h2_144; real weights_h2_145; real weights_h2_146; real weights_h2_147; real weights_h2_148; real weights_h2_149;
    real weights_h2_150; real weights_h2_151; real weights_h2_152; real weights_h2_153; real weights_h2_154; real weights_h2_155; real weights_h2_156; real weights_h2_157; real weights_h2_158; real weights_h2_159;
    real weights_h2_160; real weights_h2_161; real weights_h2_162; real weights_h2_163; real weights_h2_164; real weights_h2_165; real weights_h2_166; real weights_h2_167; real weights_h2_168; real weights_h2_169;
    real weights_h2_170; real weights_h2_171; real weights_h2_172; real weights_h2_173; real weights_h2_174; real weights_h2_175; real weights_h2_176; real weights_h2_177; real weights_h2_178; real weights_h2_179;
    real weights_h2_180; real weights_h2_181; real weights_h2_182; real weights_h2_183; real weights_h2_184; real weights_h2_185; real weights_h2_186; real weights_h2_187; real weights_h2_188; real weights_h2_189;
    real weights_h2_190; real weights_h2_191; real weights_h2_192; real weights_h2_193; real weights_h2_194; real weights_h2_195; real weights_h2_196; real weights_h2_197; real weights_h2_198; real weights_h2_199;
    real weights_h2_200; real weights_h2_201; real weights_h2_202; real weights_h2_203; real weights_h2_204; real weights_h2_205; real weights_h2_206; real weights_h2_207; real weights_h2_208; real weights_h2_209;
    real weights_h2_210; real weights_h2_211; real weights_h2_212; real weights_h2_213; real weights_h2_214; real weights_h2_215; real weights_h2_216; real weights_h2_217; real weights_h2_218; real weights_h2_219;
    real weights_h2_220; real weights_h2_221; real weights_h2_222; real weights_h2_223; real weights_h2_224; real weights_h2_225; real weights_h2_226; real weights_h2_227; real weights_h2_228; real weights_h2_229;
    real weights_h2_230; real weights_h2_231; real weights_h2_232; real weights_h2_233; real weights_h2_234; real weights_h2_235; real weights_h2_236; real weights_h2_237; real weights_h2_238; real weights_h2_239;
    real weights_h2_240; real weights_h2_241; real weights_h2_242; real weights_h2_243; real weights_h2_244; real weights_h2_245; real weights_h2_246; real weights_h2_247; real weights_h2_248; real weights_h2_249;
    real weights_h2_250; real weights_h2_251; real weights_h2_252; real weights_h2_253; real weights_h2_254; real weights_h2_255; real weights_h2_256; real weights_h2_257; real weights_h2_258; real weights_h2_259;
    real weights_h2_260; real weights_h2_261; real weights_h2_262; real weights_h2_263; real weights_h2_264; real weights_h2_265; real weights_h2_266; real weights_h2_267; real weights_h2_268; real weights_h2_269;
    real weights_h2_270; real weights_h2_271; real weights_h2_272; real weights_h2_273; real weights_h2_274; real weights_h2_275; real weights_h2_276; real weights_h2_277; real weights_h2_278; real weights_h2_279;
    real weights_h2_280; real weights_h2_281; real weights_h2_282; real weights_h2_283; real weights_h2_284; real weights_h2_285; real weights_h2_286; real weights_h2_287; real weights_h2_288; real weights_h2_289;
    real weights_h2_290; real weights_h2_291; real weights_h2_292; real weights_h2_293; real weights_h2_294; real weights_h2_295; real weights_h2_296; real weights_h2_297; real weights_h2_298; real weights_h2_299;
    real weights_h2_300; real weights_h2_301; real weights_h2_302; real weights_h2_303; real weights_h2_304; real weights_h2_305; real weights_h2_306; real weights_h2_307; real weights_h2_308; real weights_h2_309;
    real weights_h2_310; real weights_h2_311; real weights_h2_312; real weights_h2_313; real weights_h2_314; real weights_h2_315; real weights_h2_316; real weights_h2_317; real weights_h2_318; real weights_h2_319;
    real weights_h2_320; real weights_h2_321; real weights_h2_322; real weights_h2_323; real weights_h2_324; real weights_h2_325; real weights_h2_326; real weights_h2_327; real weights_h2_328; real weights_h2_329;
    real weights_h2_330; real weights_h2_331; real weights_h2_332; real weights_h2_333; real weights_h2_334; real weights_h2_335; real weights_h2_336; real weights_h2_337; real weights_h2_338; real weights_h2_339;
    real weights_h2_340; real weights_h2_341; real weights_h2_342; real weights_h2_343; real weights_h2_344; real weights_h2_345; real weights_h2_346; real weights_h2_347; real weights_h2_348; real weights_h2_349;
    real weights_h2_350; real weights_h2_351; real weights_h2_352; real weights_h2_353; real weights_h2_354; real weights_h2_355; real weights_h2_356; real weights_h2_357; real weights_h2_358; real weights_h2_359;
    real weights_h2_360; real weights_h2_361; real weights_h2_362; real weights_h2_363; real weights_h2_364; real weights_h2_365; real weights_h2_366; real weights_h2_367; real weights_h2_368; real weights_h2_369;
    real weights_h2_370; real weights_h2_371; real weights_h2_372; real weights_h2_373; real weights_h2_374; real weights_h2_375; real weights_h2_376; real weights_h2_377; real weights_h2_378; real weights_h2_379;
    real weights_h2_380; real weights_h2_381; real weights_h2_382; real weights_h2_383; real weights_h2_384; real weights_h2_385; real weights_h2_386; real weights_h2_387; real weights_h2_388; real weights_h2_389;
    real weights_h2_390; real weights_h2_391; real weights_h2_392; real weights_h2_393; real weights_h2_394; real weights_h2_395; real weights_h2_396; real weights_h2_397; real weights_h2_398; real weights_h2_399;
    real weights_h2_400; real weights_h2_401; real weights_h2_402; real weights_h2_403; real weights_h2_404; real weights_h2_405; real weights_h2_406; real weights_h2_407; real weights_h2_408; real weights_h2_409;
    real weights_h2_410; real weights_h2_411; real weights_h2_412; real weights_h2_413; real weights_h2_414; real weights_h2_415; real weights_h2_416; real weights_h2_417; real weights_h2_418; real weights_h2_419;
    real weights_h2_420; real weights_h2_421; real weights_h2_422; real weights_h2_423; real weights_h2_424; real weights_h2_425; real weights_h2_426; real weights_h2_427; real weights_h2_428; real weights_h2_429;
    real weights_h2_430; real weights_h2_431; real weights_h2_432; real weights_h2_433; real weights_h2_434; real weights_h2_435; real weights_h2_436; real weights_h2_437; real weights_h2_438; real weights_h2_439;
    real weights_h2_440; real weights_h2_441; real weights_h2_442; real weights_h2_443; real weights_h2_444; real weights_h2_445; real weights_h2_446; real weights_h2_447; real weights_h2_448; real weights_h2_449;
    real weights_h2_450; real weights_h2_451; real weights_h2_452; real weights_h2_453; real weights_h2_454; real weights_h2_455; real weights_h2_456; real weights_h2_457; real weights_h2_458; real weights_h2_459;
    real weights_h2_460; real weights_h2_461; real weights_h2_462; real weights_h2_463; real weights_h2_464; real weights_h2_465; real weights_h2_466; real weights_h2_467; real weights_h2_468; real weights_h2_469;
    real weights_h2_470; real weights_h2_471; real weights_h2_472; real weights_h2_473; real weights_h2_474; real weights_h2_475; real weights_h2_476; real weights_h2_477; real weights_h2_478; real weights_h2_479;
    real weights_h2_480; real weights_h2_481; real weights_h2_482; real weights_h2_483; real weights_h2_484; real weights_h2_485; real weights_h2_486; real weights_h2_487; real weights_h2_488; real weights_h2_489;
    real weights_h2_490; real weights_h2_491; real weights_h2_492; real weights_h2_493; real weights_h2_494; real weights_h2_495; real weights_h2_496; real weights_h2_497; real weights_h2_498; real weights_h2_499;
    real weights_h2_500; real weights_h2_501; real weights_h2_502; real weights_h2_503; real weights_h2_504; real weights_h2_505; real weights_h2_506; real weights_h2_507; real weights_h2_508; real weights_h2_509;
    real weights_h2_510; real weights_h2_511; real weights_h2_512; real weights_h2_513; real weights_h2_514; real weights_h2_515; real weights_h2_516; real weights_h2_517; real weights_h2_518; real weights_h2_519;
    real weights_h2_520; real weights_h2_521; real weights_h2_522; real weights_h2_523; real weights_h2_524; real weights_h2_525; real weights_h2_526; real weights_h2_527; real weights_h2_528; real weights_h2_529;
    real weights_h2_530; real weights_h2_531; real weights_h2_532; real weights_h2_533; real weights_h2_534; real weights_h2_535; real weights_h2_536; real weights_h2_537; real weights_h2_538; real weights_h2_539;
    real weights_h2_540; real weights_h2_541; real weights_h2_542; real weights_h2_543; real weights_h2_544; real weights_h2_545; real weights_h2_546; real weights_h2_547; real weights_h2_548; real weights_h2_549;
    real weights_h2_550; real weights_h2_551; real weights_h2_552; real weights_h2_553; real weights_h2_554; real weights_h2_555; real weights_h2_556; real weights_h2_557; real weights_h2_558; real weights_h2_559;
    real weights_h2_560; real weights_h2_561; real weights_h2_562; real weights_h2_563; real weights_h2_564; real weights_h2_565; real weights_h2_566; real weights_h2_567; real weights_h2_568; real weights_h2_569;
    real weights_h2_570; real weights_h2_571; real weights_h2_572; real weights_h2_573; real weights_h2_574; real weights_h2_575; real weights_h2_576; real weights_h2_577; real weights_h2_578; real weights_h2_579;
    real weights_h2_580; real weights_h2_581; real weights_h2_582; real weights_h2_583; real weights_h2_584; real weights_h2_585; real weights_h2_586; real weights_h2_587; real weights_h2_588; real weights_h2_589;
    real weights_h2_590; real weights_h2_591; real weights_h2_592; real weights_h2_593; real weights_h2_594; real weights_h2_595; real weights_h2_596; real weights_h2_597; real weights_h2_598; real weights_h2_599;
    real weights_h2_600; real weights_h2_601; real weights_h2_602; real weights_h2_603; real weights_h2_604; real weights_h2_605; real weights_h2_606; real weights_h2_607; real weights_h2_608; real weights_h2_609;
    real weights_h2_610; real weights_h2_611; real weights_h2_612; real weights_h2_613; real weights_h2_614; real weights_h2_615; real weights_h2_616; real weights_h2_617; real weights_h2_618; real weights_h2_619;
    real weights_h2_620; real weights_h2_621; real weights_h2_622; real weights_h2_623; real weights_h2_624; real weights_h2_625; real weights_h2_626; real weights_h2_627; real weights_h2_628; real weights_h2_629;
    real weights_h2_630; real weights_h2_631; real weights_h2_632; real weights_h2_633; real weights_h2_634; real weights_h2_635; real weights_h2_636; real weights_h2_637; real weights_h2_638; real weights_h2_639;
    real weights_h2_640; real weights_h2_641; real weights_h2_642; real weights_h2_643; real weights_h2_644; real weights_h2_645; real weights_h2_646; real weights_h2_647; real weights_h2_648; real weights_h2_649;
    real weights_h2_650; real weights_h2_651; real weights_h2_652; real weights_h2_653; real weights_h2_654; real weights_h2_655; real weights_h2_656; real weights_h2_657; real weights_h2_658; real weights_h2_659;
    real weights_h2_660; real weights_h2_661; real weights_h2_662; real weights_h2_663; real weights_h2_664; real weights_h2_665; real weights_h2_666; real weights_h2_667; real weights_h2_668; real weights_h2_669;
    real weights_h2_670; real weights_h2_671; real weights_h2_672; real weights_h2_673; real weights_h2_674; real weights_h2_675; real weights_h2_676; real weights_h2_677; real weights_h2_678; real weights_h2_679;
    real weights_h2_680; real weights_h2_681; real weights_h2_682; real weights_h2_683; real weights_h2_684; real weights_h2_685; real weights_h2_686; real weights_h2_687; real weights_h2_688; real weights_h2_689;
    real weights_h2_690; real weights_h2_691; real weights_h2_692; real weights_h2_693; real weights_h2_694; real weights_h2_695; real weights_h2_696; real weights_h2_697; real weights_h2_698; real weights_h2_699;
    real weights_h2_700; real weights_h2_701; real weights_h2_702; real weights_h2_703; real weights_h2_704; real weights_h2_705; real weights_h2_706; real weights_h2_707; real weights_h2_708; real weights_h2_709;
    real weights_h2_710; real weights_h2_711; real weights_h2_712; real weights_h2_713; real weights_h2_714; real weights_h2_715; real weights_h2_716; real weights_h2_717; real weights_h2_718; real weights_h2_719;
    real weights_h2_720; real weights_h2_721; real weights_h2_722; real weights_h2_723; real weights_h2_724; real weights_h2_725; real weights_h2_726; real weights_h2_727; real weights_h2_728; real weights_h2_729;
    real weights_h2_730; real weights_h2_731; real weights_h2_732; real weights_h2_733; real weights_h2_734; real weights_h2_735; real weights_h2_736; real weights_h2_737; real weights_h2_738; real weights_h2_739;
    real weights_h2_740; real weights_h2_741; real weights_h2_742; real weights_h2_743; real weights_h2_744; real weights_h2_745; real weights_h2_746; real weights_h2_747; real weights_h2_748; real weights_h2_749;
    real weights_h2_750; real weights_h2_751; real weights_h2_752; real weights_h2_753; real weights_h2_754; real weights_h2_755; real weights_h2_756; real weights_h2_757; real weights_h2_758; real weights_h2_759;
    real weights_h2_760; real weights_h2_761; real weights_h2_762; real weights_h2_763; real weights_h2_764; real weights_h2_765; real weights_h2_766; real weights_h2_767; real weights_h2_768; real weights_h2_769;
    real weights_h2_770; real weights_h2_771; real weights_h2_772; real weights_h2_773; real weights_h2_774; real weights_h2_775; real weights_h2_776; real weights_h2_777; real weights_h2_778; real weights_h2_779;
    real weights_h2_780; real weights_h2_781; real weights_h2_782; real weights_h2_783; real weights_h2_784; real weights_h2_785; real weights_h2_786; real weights_h2_787; real weights_h2_788; real weights_h2_789;
    real weights_h2_790; real weights_h2_791; real weights_h2_792; real weights_h2_793; real weights_h2_794; real weights_h2_795; real weights_h2_796; real weights_h2_797; real weights_h2_798; real weights_h2_799;
    real weights_h2_800; real weights_h2_801; real weights_h2_802; real weights_h2_803; real weights_h2_804; real weights_h2_805; real weights_h2_806; real weights_h2_807; real weights_h2_808; real weights_h2_809;
    real weights_h2_810; real weights_h2_811; real weights_h2_812; real weights_h2_813; real weights_h2_814; real weights_h2_815; real weights_h2_816; real weights_h2_817; real weights_h2_818; real weights_h2_819;
    real weights_h2_820; real weights_h2_821; real weights_h2_822; real weights_h2_823; real weights_h2_824; real weights_h2_825; real weights_h2_826; real weights_h2_827; real weights_h2_828; real weights_h2_829;
    real weights_h2_830; real weights_h2_831; real weights_h2_832; real weights_h2_833; real weights_h2_834; real weights_h2_835; real weights_h2_836; real weights_h2_837; real weights_h2_838; real weights_h2_839;
    real weights_h2_840; real weights_h2_841; real weights_h2_842; real weights_h2_843; real weights_h2_844; real weights_h2_845; real weights_h2_846; real weights_h2_847; real weights_h2_848; real weights_h2_849;
    real weights_h2_850; real weights_h2_851; real weights_h2_852; real weights_h2_853; real weights_h2_854; real weights_h2_855; real weights_h2_856; real weights_h2_857; real weights_h2_858; real weights_h2_859;
    real weights_h2_860; real weights_h2_861; real weights_h2_862; real weights_h2_863; real weights_h2_864; real weights_h2_865; real weights_h2_866; real weights_h2_867; real weights_h2_868; real weights_h2_869;
    real weights_h2_870; real weights_h2_871; real weights_h2_872; real weights_h2_873; real weights_h2_874; real weights_h2_875; real weights_h2_876; real weights_h2_877; real weights_h2_878; real weights_h2_879;
    real weights_h2_880; real weights_h2_881; real weights_h2_882; real weights_h2_883; real weights_h2_884; real weights_h2_885; real weights_h2_886; real weights_h2_887; real weights_h2_888; real weights_h2_889;
    real weights_h2_890; real weights_h2_891; real weights_h2_892; real weights_h2_893; real weights_h2_894; real weights_h2_895; real weights_h2_896; real weights_h2_897; real weights_h2_898; real weights_h2_899;
    real weights_h2_900; real weights_h2_901; real weights_h2_902; real weights_h2_903; real weights_h2_904; real weights_h2_905; real weights_h2_906; real weights_h2_907; real weights_h2_908; real weights_h2_909;
    real weights_h2_910; real weights_h2_911; real weights_h2_912; real weights_h2_913; real weights_h2_914; real weights_h2_915; real weights_h2_916; real weights_h2_917; real weights_h2_918; real weights_h2_919;
    real weights_h2_920; real weights_h2_921; real weights_h2_922; real weights_h2_923; real weights_h2_924; real weights_h2_925; real weights_h2_926; real weights_h2_927; real weights_h2_928; real weights_h2_929;
    real weights_h2_930; real weights_h2_931; real weights_h2_932; real weights_h2_933; real weights_h2_934; real weights_h2_935; real weights_h2_936; real weights_h2_937; real weights_h2_938; real weights_h2_939;
    real weights_h2_940; real weights_h2_941; real weights_h2_942; real weights_h2_943; real weights_h2_944; real weights_h2_945; real weights_h2_946; real weights_h2_947; real weights_h2_948; real weights_h2_949;
    real weights_h2_950; real weights_h2_951; real weights_h2_952; real weights_h2_953; real weights_h2_954; real weights_h2_955; real weights_h2_956; real weights_h2_957; real weights_h2_958; real weights_h2_959;
    real weights_h2_960; real weights_h2_961; real weights_h2_962; real weights_h2_963; real weights_h2_964; real weights_h2_965; real weights_h2_966; real weights_h2_967; real weights_h2_968; real weights_h2_969;
    real weights_h2_970; real weights_h2_971; real weights_h2_972; real weights_h2_973; real weights_h2_974; real weights_h2_975; real weights_h2_976; real weights_h2_977; real weights_h2_978; real weights_h2_979;
    real weights_h2_980; real weights_h2_981; real weights_h2_982; real weights_h2_983; real weights_h2_984; real weights_h2_985; real weights_h2_986; real weights_h2_987; real weights_h2_988; real weights_h2_989;
    real weights_h2_990; real weights_h2_991; real weights_h2_992; real weights_h2_993; real weights_h2_994; real weights_h2_995; real weights_h2_996; real weights_h2_997; real weights_h2_998; real weights_h2_999;
    real weights_h2_1000; real weights_h2_1001; real weights_h2_1002; real weights_h2_1003; real weights_h2_1004; real weights_h2_1005; real weights_h2_1006; real weights_h2_1007; real weights_h2_1008; real weights_h2_1009;
    real weights_h2_1010; real weights_h2_1011; real weights_h2_1012; real weights_h2_1013; real weights_h2_1014; real weights_h2_1015; real weights_h2_1016; real weights_h2_1017; real weights_h2_1018; real weights_h2_1019;
    real weights_h2_1020; real weights_h2_1021; real weights_h2_1022; real weights_h2_1023; real weights_h2_1024; real weights_h2_1025; real weights_h2_1026; real weights_h2_1027; real weights_h2_1028; real weights_h2_1029;
    real weights_h2_1030; real weights_h2_1031; real weights_h2_1032; real weights_h2_1033; real weights_h2_1034; real weights_h2_1035; real weights_h2_1036; real weights_h2_1037; real weights_h2_1038; real weights_h2_1039;
    real weights_h2_1040; real weights_h2_1041; real weights_h2_1042; real weights_h2_1043; real weights_h2_1044; real weights_h2_1045; real weights_h2_1046; real weights_h2_1047; real weights_h2_1048; real weights_h2_1049;
    real weights_h2_1050; real weights_h2_1051; real weights_h2_1052; real weights_h2_1053; real weights_h2_1054; real weights_h2_1055; real weights_h2_1056; real weights_h2_1057; real weights_h2_1058; real weights_h2_1059;
    real weights_h2_1060; real weights_h2_1061; real weights_h2_1062; real weights_h2_1063; real weights_h2_1064; real weights_h2_1065; real weights_h2_1066; real weights_h2_1067; real weights_h2_1068; real weights_h2_1069;
    real weights_h2_1070; real weights_h2_1071; real weights_h2_1072; real weights_h2_1073; real weights_h2_1074; real weights_h2_1075; real weights_h2_1076; real weights_h2_1077; real weights_h2_1078; real weights_h2_1079;
    real weights_h2_1080; real weights_h2_1081; real weights_h2_1082; real weights_h2_1083; real weights_h2_1084; real weights_h2_1085; real weights_h2_1086; real weights_h2_1087; real weights_h2_1088; real weights_h2_1089;
    real weights_h2_1090; real weights_h2_1091; real weights_h2_1092; real weights_h2_1093; real weights_h2_1094; real weights_h2_1095; real weights_h2_1096; real weights_h2_1097; real weights_h2_1098; real weights_h2_1099;
    real weights_h2_1100; real weights_h2_1101; real weights_h2_1102; real weights_h2_1103; real weights_h2_1104; real weights_h2_1105; real weights_h2_1106; real weights_h2_1107; real weights_h2_1108; real weights_h2_1109;
    real weights_h2_1110; real weights_h2_1111; real weights_h2_1112; real weights_h2_1113; real weights_h2_1114; real weights_h2_1115; real weights_h2_1116; real weights_h2_1117; real weights_h2_1118; real weights_h2_1119;
    real weights_h2_1120; real weights_h2_1121; real weights_h2_1122; real weights_h2_1123; real weights_h2_1124; real weights_h2_1125; real weights_h2_1126; real weights_h2_1127; real weights_h2_1128; real weights_h2_1129;
    real weights_h2_1130; real weights_h2_1131; real weights_h2_1132; real weights_h2_1133; real weights_h2_1134; real weights_h2_1135; real weights_h2_1136; real weights_h2_1137; real weights_h2_1138; real weights_h2_1139;
    real weights_h2_1140; real weights_h2_1141; real weights_h2_1142; real weights_h2_1143; real weights_h2_1144; real weights_h2_1145; real weights_h2_1146; real weights_h2_1147; real weights_h2_1148; real weights_h2_1149;
    real weights_h2_1150; real weights_h2_1151; real weights_h2_1152; real weights_h2_1153; real weights_h2_1154; real weights_h2_1155; real weights_h2_1156; real weights_h2_1157; real weights_h2_1158; real weights_h2_1159;
    real weights_h2_1160; real weights_h2_1161; real weights_h2_1162; real weights_h2_1163; real weights_h2_1164; real weights_h2_1165; real weights_h2_1166; real weights_h2_1167; real weights_h2_1168; real weights_h2_1169;
    real weights_h2_1170; real weights_h2_1171; real weights_h2_1172; real weights_h2_1173; real weights_h2_1174; real weights_h2_1175; real weights_h2_1176; real weights_h2_1177; real weights_h2_1178; real weights_h2_1179;
    real weights_h2_1180; real weights_h2_1181; real weights_h2_1182; real weights_h2_1183; real weights_h2_1184; real weights_h2_1185; real weights_h2_1186; real weights_h2_1187; real weights_h2_1188; real weights_h2_1189;
    real weights_h2_1190; real weights_h2_1191; real weights_h2_1192; real weights_h2_1193; real weights_h2_1194; real weights_h2_1195; real weights_h2_1196; real weights_h2_1197; real weights_h2_1198; real weights_h2_1199;
    real weights_h2_1200; real weights_h2_1201; real weights_h2_1202; real weights_h2_1203; real weights_h2_1204; real weights_h2_1205; real weights_h2_1206; real weights_h2_1207; real weights_h2_1208; real weights_h2_1209;
    real weights_h2_1210; real weights_h2_1211; real weights_h2_1212; real weights_h2_1213; real weights_h2_1214; real weights_h2_1215; real weights_h2_1216; real weights_h2_1217; real weights_h2_1218; real weights_h2_1219;
    real weights_h2_1220; real weights_h2_1221; real weights_h2_1222; real weights_h2_1223; real weights_h2_1224; real weights_h2_1225; real weights_h2_1226; real weights_h2_1227; real weights_h2_1228; real weights_h2_1229;
    real weights_h2_1230; real weights_h2_1231; real weights_h2_1232; real weights_h2_1233; real weights_h2_1234; real weights_h2_1235; real weights_h2_1236; real weights_h2_1237; real weights_h2_1238; real weights_h2_1239;
    real weights_h2_1240; real weights_h2_1241; real weights_h2_1242; real weights_h2_1243; real weights_h2_1244; real weights_h2_1245; real weights_h2_1246; real weights_h2_1247; real weights_h2_1248; real weights_h2_1249;
    real weights_h2_1250; real weights_h2_1251; real weights_h2_1252; real weights_h2_1253; real weights_h2_1254; real weights_h2_1255; real weights_h2_1256; real weights_h2_1257; real weights_h2_1258; real weights_h2_1259;
    real weights_h2_1260; real weights_h2_1261; real weights_h2_1262; real weights_h2_1263; real weights_h2_1264; real weights_h2_1265; real weights_h2_1266; real weights_h2_1267; real weights_h2_1268; real weights_h2_1269;
    real weights_h2_1270; real weights_h2_1271; real weights_h2_1272; real weights_h2_1273; real weights_h2_1274; real weights_h2_1275; real weights_h2_1276; real weights_h2_1277; real weights_h2_1278; real weights_h2_1279;
    real weights_h2_1280; real weights_h2_1281; real weights_h2_1282; real weights_h2_1283; real weights_h2_1284; real weights_h2_1285; real weights_h2_1286; real weights_h2_1287; real weights_h2_1288; real weights_h2_1289;
    real weights_h2_1290; real weights_h2_1291; real weights_h2_1292; real weights_h2_1293; real weights_h2_1294; real weights_h2_1295; real weights_h2_1296; real weights_h2_1297; real weights_h2_1298; real weights_h2_1299;
    real weights_h2_1300; real weights_h2_1301; real weights_h2_1302; real weights_h2_1303; real weights_h2_1304; real weights_h2_1305; real weights_h2_1306; real weights_h2_1307; real weights_h2_1308; real weights_h2_1309;
    real weights_h2_1310; real weights_h2_1311; real weights_h2_1312; real weights_h2_1313; real weights_h2_1314; real weights_h2_1315; real weights_h2_1316; real weights_h2_1317; real weights_h2_1318; real weights_h2_1319;
    real weights_h2_1320; real weights_h2_1321; real weights_h2_1322; real weights_h2_1323; real weights_h2_1324; real weights_h2_1325; real weights_h2_1326; real weights_h2_1327; real weights_h2_1328; real weights_h2_1329;
    real weights_h2_1330; real weights_h2_1331; real weights_h2_1332; real weights_h2_1333; real weights_h2_1334; real weights_h2_1335; real weights_h2_1336; real weights_h2_1337; real weights_h2_1338; real weights_h2_1339;
    real weights_h2_1340; real weights_h2_1341; real weights_h2_1342; real weights_h2_1343; real weights_h2_1344; real weights_h2_1345; real weights_h2_1346; real weights_h2_1347; real weights_h2_1348; real weights_h2_1349;
    real weights_h2_1350; real weights_h2_1351; real weights_h2_1352; real weights_h2_1353; real weights_h2_1354; real weights_h2_1355; real weights_h2_1356; real weights_h2_1357; real weights_h2_1358; real weights_h2_1359;
    real weights_h2_1360; real weights_h2_1361; real weights_h2_1362; real weights_h2_1363; real weights_h2_1364; real weights_h2_1365; real weights_h2_1366; real weights_h2_1367; real weights_h2_1368; real weights_h2_1369;
    real weights_h2_1370; real weights_h2_1371; real weights_h2_1372; real weights_h2_1373; real weights_h2_1374; real weights_h2_1375; real weights_h2_1376; real weights_h2_1377; real weights_h2_1378; real weights_h2_1379;
    real weights_h2_1380; real weights_h2_1381; real weights_h2_1382; real weights_h2_1383; real weights_h2_1384; real weights_h2_1385; real weights_h2_1386; real weights_h2_1387; real weights_h2_1388; real weights_h2_1389;
    real weights_h2_1390; real weights_h2_1391; real weights_h2_1392; real weights_h2_1393; real weights_h2_1394; real weights_h2_1395; real weights_h2_1396; real weights_h2_1397; real weights_h2_1398; real weights_h2_1399;
    real weights_h2_1400; real weights_h2_1401; real weights_h2_1402; real weights_h2_1403; real weights_h2_1404; real weights_h2_1405; real weights_h2_1406; real weights_h2_1407; real weights_h2_1408; real weights_h2_1409;
    real weights_h2_1410; real weights_h2_1411; real weights_h2_1412; real weights_h2_1413; real weights_h2_1414; real weights_h2_1415; real weights_h2_1416; real weights_h2_1417; real weights_h2_1418; real weights_h2_1419;
    real weights_h2_1420; real weights_h2_1421; real weights_h2_1422; real weights_h2_1423; real weights_h2_1424; real weights_h2_1425; real weights_h2_1426; real weights_h2_1427; real weights_h2_1428; real weights_h2_1429;
    real weights_h2_1430; real weights_h2_1431; real weights_h2_1432; real weights_h2_1433; real weights_h2_1434; real weights_h2_1435; real weights_h2_1436; real weights_h2_1437; real weights_h2_1438; real weights_h2_1439;
    real weights_h2_1440; real weights_h2_1441; real weights_h2_1442; real weights_h2_1443; real weights_h2_1444; real weights_h2_1445; real weights_h2_1446; real weights_h2_1447; real weights_h2_1448; real weights_h2_1449;
    real weights_h2_1450; real weights_h2_1451; real weights_h2_1452; real weights_h2_1453; real weights_h2_1454; real weights_h2_1455; real weights_h2_1456; real weights_h2_1457; real weights_h2_1458; real weights_h2_1459;
    real weights_h2_1460; real weights_h2_1461; real weights_h2_1462; real weights_h2_1463; real weights_h2_1464; real weights_h2_1465; real weights_h2_1466; real weights_h2_1467; real weights_h2_1468; real weights_h2_1469;
    real weights_h2_1470; real weights_h2_1471; real weights_h2_1472; real weights_h2_1473; real weights_h2_1474; real weights_h2_1475; real weights_h2_1476; real weights_h2_1477; real weights_h2_1478; real weights_h2_1479;
    real weights_h2_1480; real weights_h2_1481; real weights_h2_1482; real weights_h2_1483; real weights_h2_1484; real weights_h2_1485; real weights_h2_1486; real weights_h2_1487; real weights_h2_1488; real weights_h2_1489;
    real weights_h2_1490; real weights_h2_1491; real weights_h2_1492; real weights_h2_1493; real weights_h2_1494; real weights_h2_1495; real weights_h2_1496; real weights_h2_1497; real weights_h2_1498; real weights_h2_1499;
    real weights_h2_1500; real weights_h2_1501; real weights_h2_1502; real weights_h2_1503; real weights_h2_1504; real weights_h2_1505; real weights_h2_1506; real weights_h2_1507; real weights_h2_1508; real weights_h2_1509;
    real weights_h2_1510; real weights_h2_1511; real weights_h2_1512; real weights_h2_1513; real weights_h2_1514; real weights_h2_1515; real weights_h2_1516; real weights_h2_1517; real weights_h2_1518; real weights_h2_1519;
    real weights_h2_1520; real weights_h2_1521; real weights_h2_1522; real weights_h2_1523; real weights_h2_1524; real weights_h2_1525; real weights_h2_1526; real weights_h2_1527; real weights_h2_1528; real weights_h2_1529;
    real weights_h2_1530; real weights_h2_1531; real weights_h2_1532; real weights_h2_1533; real weights_h2_1534; real weights_h2_1535; real weights_h2_1536; real weights_h2_1537; real weights_h2_1538; real weights_h2_1539;
    real weights_h2_1540; real weights_h2_1541; real weights_h2_1542; real weights_h2_1543; real weights_h2_1544; real weights_h2_1545; real weights_h2_1546; real weights_h2_1547; real weights_h2_1548; real weights_h2_1549;
    real weights_h2_1550; real weights_h2_1551; real weights_h2_1552; real weights_h2_1553; real weights_h2_1554; real weights_h2_1555; real weights_h2_1556; real weights_h2_1557; real weights_h2_1558; real weights_h2_1559;
    real weights_h2_1560; real weights_h2_1561; real weights_h2_1562; real weights_h2_1563; real weights_h2_1564; real weights_h2_1565; real weights_h2_1566; real weights_h2_1567; real weights_h2_1568; real weights_h2_1569;
    real weights_h2_1570; real weights_h2_1571; real weights_h2_1572; real weights_h2_1573; real weights_h2_1574; real weights_h2_1575; real weights_h2_1576; real weights_h2_1577; real weights_h2_1578; real weights_h2_1579;
    real weights_h2_1580; real weights_h2_1581; real weights_h2_1582; real weights_h2_1583; real weights_h2_1584; real weights_h2_1585; real weights_h2_1586; real weights_h2_1587; real weights_h2_1588; real weights_h2_1589;
    real weights_h2_1590; real weights_h2_1591; real weights_h2_1592; real weights_h2_1593; real weights_h2_1594; real weights_h2_1595; real weights_h2_1596; real weights_h2_1597; real weights_h2_1598; real weights_h2_1599;
    real weights_h2_1600; real weights_h2_1601; real weights_h2_1602; real weights_h2_1603; real weights_h2_1604; real weights_h2_1605; real weights_h2_1606; real weights_h2_1607; real weights_h2_1608; real weights_h2_1609;
    real weights_h2_1610; real weights_h2_1611; real weights_h2_1612; real weights_h2_1613; real weights_h2_1614; real weights_h2_1615; real weights_h2_1616; real weights_h2_1617; real weights_h2_1618; real weights_h2_1619;
    real weights_h2_1620; real weights_h2_1621; real weights_h2_1622; real weights_h2_1623; real weights_h2_1624; real weights_h2_1625; real weights_h2_1626; real weights_h2_1627; real weights_h2_1628; real weights_h2_1629;
    real weights_h2_1630; real weights_h2_1631; real weights_h2_1632; real weights_h2_1633; real weights_h2_1634; real weights_h2_1635; real weights_h2_1636; real weights_h2_1637; real weights_h2_1638; real weights_h2_1639;
    real weights_h2_1640; real weights_h2_1641; real weights_h2_1642; real weights_h2_1643; real weights_h2_1644; real weights_h2_1645; real weights_h2_1646; real weights_h2_1647; real weights_h2_1648; real weights_h2_1649;
    real weights_h2_1650; real weights_h2_1651; real weights_h2_1652; real weights_h2_1653; real weights_h2_1654; real weights_h2_1655; real weights_h2_1656; real weights_h2_1657; real weights_h2_1658; real weights_h2_1659;
    real weights_h2_1660; real weights_h2_1661; real weights_h2_1662; real weights_h2_1663; real weights_h2_1664; real weights_h2_1665; real weights_h2_1666; real weights_h2_1667; real weights_h2_1668; real weights_h2_1669;
    real weights_h2_1670; real weights_h2_1671; real weights_h2_1672; real weights_h2_1673; real weights_h2_1674; real weights_h2_1675; real weights_h2_1676; real weights_h2_1677; real weights_h2_1678; real weights_h2_1679;
    real weights_h2_1680; real weights_h2_1681; real weights_h2_1682; real weights_h2_1683; real weights_h2_1684; real weights_h2_1685; real weights_h2_1686; real weights_h2_1687; real weights_h2_1688; real weights_h2_1689;
    real weights_h2_1690; real weights_h2_1691; real weights_h2_1692; real weights_h2_1693; real weights_h2_1694; real weights_h2_1695; real weights_h2_1696; real weights_h2_1697; real weights_h2_1698; real weights_h2_1699;
    real weights_h2_1700; real weights_h2_1701; real weights_h2_1702; real weights_h2_1703; real weights_h2_1704; real weights_h2_1705; real weights_h2_1706; real weights_h2_1707; real weights_h2_1708; real weights_h2_1709;
    real weights_h2_1710; real weights_h2_1711; real weights_h2_1712; real weights_h2_1713; real weights_h2_1714; real weights_h2_1715; real weights_h2_1716; real weights_h2_1717; real weights_h2_1718; real weights_h2_1719;
    real weights_h2_1720; real weights_h2_1721; real weights_h2_1722; real weights_h2_1723; real weights_h2_1724; real weights_h2_1725; real weights_h2_1726; real weights_h2_1727; real weights_h2_1728; real weights_h2_1729;
    real weights_h2_1730; real weights_h2_1731; real weights_h2_1732; real weights_h2_1733; real weights_h2_1734; real weights_h2_1735; real weights_h2_1736; real weights_h2_1737; real weights_h2_1738; real weights_h2_1739;
    real weights_h2_1740; real weights_h2_1741; real weights_h2_1742; real weights_h2_1743; real weights_h2_1744; real weights_h2_1745; real weights_h2_1746; real weights_h2_1747; real weights_h2_1748; real weights_h2_1749;
    real weights_h2_1750; real weights_h2_1751; real weights_h2_1752; real weights_h2_1753; real weights_h2_1754; real weights_h2_1755; real weights_h2_1756; real weights_h2_1757; real weights_h2_1758; real weights_h2_1759;
    real weights_h2_1760; real weights_h2_1761; real weights_h2_1762; real weights_h2_1763; real weights_h2_1764; real weights_h2_1765; real weights_h2_1766; real weights_h2_1767; real weights_h2_1768; real weights_h2_1769;
    real weights_h2_1770; real weights_h2_1771; real weights_h2_1772; real weights_h2_1773; real weights_h2_1774; real weights_h2_1775; real weights_h2_1776; real weights_h2_1777; real weights_h2_1778; real weights_h2_1779;
    real weights_h2_1780; real weights_h2_1781; real weights_h2_1782; real weights_h2_1783; real weights_h2_1784; real weights_h2_1785; real weights_h2_1786; real weights_h2_1787; real weights_h2_1788; real weights_h2_1789;
    real weights_h2_1790; real weights_h2_1791; real weights_h2_1792; real weights_h2_1793; real weights_h2_1794; real weights_h2_1795; real weights_h2_1796; real weights_h2_1797; real weights_h2_1798; real weights_h2_1799;
    real weights_h2_1800; real weights_h2_1801; real weights_h2_1802; real weights_h2_1803; real weights_h2_1804; real weights_h2_1805; real weights_h2_1806; real weights_h2_1807; real weights_h2_1808; real weights_h2_1809;
    real weights_h2_1810; real weights_h2_1811; real weights_h2_1812; real weights_h2_1813; real weights_h2_1814; real weights_h2_1815; real weights_h2_1816; real weights_h2_1817; real weights_h2_1818; real weights_h2_1819;
    real weights_h2_1820; real weights_h2_1821; real weights_h2_1822; real weights_h2_1823; real weights_h2_1824; real weights_h2_1825; real weights_h2_1826; real weights_h2_1827; real weights_h2_1828; real weights_h2_1829;
    real weights_h2_1830; real weights_h2_1831; real weights_h2_1832; real weights_h2_1833; real weights_h2_1834; real weights_h2_1835; real weights_h2_1836; real weights_h2_1837; real weights_h2_1838; real weights_h2_1839;
    real weights_h2_1840; real weights_h2_1841; real weights_h2_1842; real weights_h2_1843; real weights_h2_1844; real weights_h2_1845; real weights_h2_1846; real weights_h2_1847; real weights_h2_1848; real weights_h2_1849;
    real weights_h2_1850; real weights_h2_1851; real weights_h2_1852; real weights_h2_1853; real weights_h2_1854; real weights_h2_1855; real weights_h2_1856; real weights_h2_1857; real weights_h2_1858; real weights_h2_1859;
    real weights_h2_1860; real weights_h2_1861; real weights_h2_1862; real weights_h2_1863; real weights_h2_1864; real weights_h2_1865; real weights_h2_1866; real weights_h2_1867; real weights_h2_1868; real weights_h2_1869;
    real weights_h2_1870; real weights_h2_1871; real weights_h2_1872; real weights_h2_1873; real weights_h2_1874; real weights_h2_1875; real weights_h2_1876; real weights_h2_1877; real weights_h2_1878; real weights_h2_1879;
    real weights_h2_1880; real weights_h2_1881; real weights_h2_1882; real weights_h2_1883; real weights_h2_1884; real weights_h2_1885; real weights_h2_1886; real weights_h2_1887; real weights_h2_1888; real weights_h2_1889;
    real weights_h2_1890; real weights_h2_1891; real weights_h2_1892; real weights_h2_1893; real weights_h2_1894; real weights_h2_1895; real weights_h2_1896; real weights_h2_1897; real weights_h2_1898; real weights_h2_1899;
    real weights_h2_1900; real weights_h2_1901; real weights_h2_1902; real weights_h2_1903; real weights_h2_1904; real weights_h2_1905; real weights_h2_1906; real weights_h2_1907; real weights_h2_1908; real weights_h2_1909;
    real weights_h2_1910; real weights_h2_1911; real weights_h2_1912; real weights_h2_1913; real weights_h2_1914; real weights_h2_1915; real weights_h2_1916; real weights_h2_1917; real weights_h2_1918; real weights_h2_1919;
    real weights_h2_1920; real weights_h2_1921; real weights_h2_1922; real weights_h2_1923; real weights_h2_1924; real weights_h2_1925; real weights_h2_1926; real weights_h2_1927; real weights_h2_1928; real weights_h2_1929;
    real weights_h2_1930; real weights_h2_1931; real weights_h2_1932; real weights_h2_1933; real weights_h2_1934; real weights_h2_1935; real weights_h2_1936; real weights_h2_1937; real weights_h2_1938; real weights_h2_1939;
    real weights_h2_1940; real weights_h2_1941; real weights_h2_1942; real weights_h2_1943; real weights_h2_1944; real weights_h2_1945; real weights_h2_1946; real weights_h2_1947; real weights_h2_1948; real weights_h2_1949;
    real weights_h2_1950; real weights_h2_1951; real weights_h2_1952; real weights_h2_1953; real weights_h2_1954; real weights_h2_1955; real weights_h2_1956; real weights_h2_1957; real weights_h2_1958; real weights_h2_1959;
    real weights_h2_1960; real weights_h2_1961; real weights_h2_1962; real weights_h2_1963; real weights_h2_1964; real weights_h2_1965; real weights_h2_1966; real weights_h2_1967; real weights_h2_1968; real weights_h2_1969;
    real weights_h2_1970; real weights_h2_1971; real weights_h2_1972; real weights_h2_1973; real weights_h2_1974; real weights_h2_1975; real weights_h2_1976; real weights_h2_1977; real weights_h2_1978; real weights_h2_1979;
    real weights_h2_1980; real weights_h2_1981; real weights_h2_1982; real weights_h2_1983; real weights_h2_1984; real weights_h2_1985; real weights_h2_1986; real weights_h2_1987; real weights_h2_1988; real weights_h2_1989;
    real weights_h2_1990; real weights_h2_1991; real weights_h2_1992; real weights_h2_1993; real weights_h2_1994; real weights_h2_1995; real weights_h2_1996; real weights_h2_1997; real weights_h2_1998; real weights_h2_1999;
    real weights_h2_2000; real weights_h2_2001; real weights_h2_2002; real weights_h2_2003; real weights_h2_2004; real weights_h2_2005; real weights_h2_2006; real weights_h2_2007; real weights_h2_2008; real weights_h2_2009;
    real weights_h2_2010; real weights_h2_2011; real weights_h2_2012; real weights_h2_2013; real weights_h2_2014; real weights_h2_2015; real weights_h2_2016; real weights_h2_2017; real weights_h2_2018; real weights_h2_2019;
    real weights_h2_2020; real weights_h2_2021; real weights_h2_2022; real weights_h2_2023; real weights_h2_2024; real weights_h2_2025; real weights_h2_2026; real weights_h2_2027; real weights_h2_2028; real weights_h2_2029;
    real weights_h2_2030; real weights_h2_2031; real weights_h2_2032; real weights_h2_2033; real weights_h2_2034; real weights_h2_2035; real weights_h2_2036; real weights_h2_2037; real weights_h2_2038; real weights_h2_2039;
    real weights_h2_2040; real weights_h2_2041; real weights_h2_2042; real weights_h2_2043; real weights_h2_2044; real weights_h2_2045; real weights_h2_2046; real weights_h2_2047;
    real bias_h2_0; real bias_h2_1; real bias_h2_2; real bias_h2_3; real bias_h2_4; real bias_h2_5; real bias_h2_6; real bias_h2_7; real bias_h2_8; real bias_h2_9;
    real bias_h2_10; real bias_h2_11; real bias_h2_12; real bias_h2_13; real bias_h2_14; real bias_h2_15; real bias_h2_16; real bias_h2_17; real bias_h2_18; real bias_h2_19;
    real bias_h2_20; real bias_h2_21; real bias_h2_22; real bias_h2_23; real bias_h2_24; real bias_h2_25; real bias_h2_26; real bias_h2_27; real bias_h2_28; real bias_h2_29;
    real bias_h2_30; real bias_h2_31; real bias_h2_32; real bias_h2_33; real bias_h2_34; real bias_h2_35; real bias_h2_36; real bias_h2_37; real bias_h2_38; real bias_h2_39;
    real bias_h2_40; real bias_h2_41; real bias_h2_42; real bias_h2_43; real bias_h2_44; real bias_h2_45; real bias_h2_46; real bias_h2_47; real bias_h2_48; real bias_h2_49;
    real bias_h2_50; real bias_h2_51; real bias_h2_52; real bias_h2_53; real bias_h2_54; real bias_h2_55; real bias_h2_56; real bias_h2_57; real bias_h2_58; real bias_h2_59;
    real bias_h2_60; real bias_h2_61; real bias_h2_62; real bias_h2_63;
    real weights_out_0; real weights_out_1; real weights_out_2; real weights_out_3; real weights_out_4; real weights_out_5; real weights_out_6; real weights_out_7; real weights_out_8; real weights_out_9;
    real weights_out_10; real weights_out_11; real weights_out_12; real weights_out_13; real weights_out_14; real weights_out_15; real weights_out_16; real weights_out_17; real weights_out_18; real weights_out_19;
    real weights_out_20; real weights_out_21; real weights_out_22; real weights_out_23; real weights_out_24; real weights_out_25; real weights_out_26; real weights_out_27; real weights_out_28; real weights_out_29;
    real weights_out_30; real weights_out_31; real weights_out_32; real weights_out_33; real weights_out_34; real weights_out_35; real weights_out_36; real weights_out_37; real weights_out_38; real weights_out_39;
    real weights_out_40; real weights_out_41; real weights_out_42; real weights_out_43; real weights_out_44; real weights_out_45; real weights_out_46; real weights_out_47; real weights_out_48; real weights_out_49;
    real weights_out_50; real weights_out_51; real weights_out_52; real weights_out_53; real weights_out_54; real weights_out_55; real weights_out_56; real weights_out_57; real weights_out_58; real weights_out_59;
    real weights_out_60; real weights_out_61; real weights_out_62; real weights_out_63;
    real bias_out_0;
    real hidden1_0; real hidden1_1; real hidden1_2; real hidden1_3; real hidden1_4; real hidden1_5; real hidden1_6; real hidden1_7; real hidden1_8; real hidden1_9; real hidden1_10; real hidden1_11; real hidden1_12; real hidden1_13; real hidden1_14; real hidden1_15; real hidden1_16; real hidden1_17; real hidden1_18; real hidden1_19; real hidden1_20; real hidden1_21; real hidden1_22; real hidden1_23; real hidden1_24; real hidden1_25; real hidden1_26; real hidden1_27; real hidden1_28; real hidden1_29; real hidden1_30; real hidden1_31;
    real hidden2_0; real hidden2_1; real hidden2_2; real hidden2_3; real hidden2_4; real hidden2_5; real hidden2_6; real hidden2_7; real hidden2_8; real hidden2_9; real hidden2_10; real hidden2_11; real hidden2_12; real hidden2_13; real hidden2_14; real hidden2_15; real hidden2_16; real hidden2_17; real hidden2_18; real hidden2_19; real hidden2_20; real hidden2_21; real hidden2_22; real hidden2_23; real hidden2_24; real hidden2_25; real hidden2_26; real hidden2_27; real hidden2_28; real hidden2_29; real hidden2_30; real hidden2_31; real hidden2_32; real hidden2_33; real hidden2_34; real hidden2_35; real hidden2_36; real hidden2_37; real hidden2_38; real hidden2_39; real hidden2_40; real hidden2_41; real hidden2_42; real hidden2_43; real hidden2_44; real hidden2_45; real hidden2_46; real hidden2_47; real hidden2_48; real hidden2_49; real hidden2_50; real hidden2_51; real hidden2_52; real hidden2_53; real hidden2_54; real hidden2_55; real hidden2_56; real hidden2_57; real hidden2_58; real hidden2_59; real hidden2_60; real hidden2_61; real hidden2_62; real hidden2_63;
    real output_0;
    real slope;
    real vce_raw, vge_raw;
    real vce_temp1, vce_temp2;
    real vge_temp1, vge_temp2;
    real ic_temp1, ic_temp2;
    real ic_raw, ic;

    analog begin
        if (weights_loaded == 0) begin
            `include "/root/autodl-tmp/my_hefner/generate_vams/vams/IGB15N60T_weights_assign.vams"
            weights_loaded = 1;
        end
        if (weights_loaded) begin
            // Input normalization

            slope = 10.0;  // Smoothing factor for soft clipping. Higher = sharper transition

            // Smoothly clip Vce to [0, Vce_max]
            vce_raw = V(a, c);
            vce_temp1 = 0.0 + (vce_raw - 0.0) / (1.0 + exp(-slope * (vce_raw - 0.0)));
            vce_temp2 = Vce_max - (Vce_max - vce_temp1) / (1.0 + exp(-slope * (vce_temp1 - Vce_max)));
            vce = vce_temp2;
            // Smoothly clip Vge to [Vge_th, Vge_max]
            vge_raw = V(g, c);
            vge_temp1 = Vge_th + (vge_raw - Vge_th) / (1.0 + exp(-slope * (vge_raw - Vge_th)));
            vge_temp2 = Vge_max - (Vge_max - vge_temp1) / (1.0 + exp(-slope * (vge_temp1 - Vge_max)));
            vge = vge_temp2;

            inputs_0 = (vge - input_mean_0) / input_std_0;
            inputs_1 = (vce - input_mean_1) / input_std_1;
            inputs_2 = (25 - input_mean_2) / input_std_2;

            // First hidden layer (32 neurons)
            hidden1_0 = $tanh(weights_h1_0 * inputs_0 + weights_h1_1 * inputs_1 + weights_h1_2 * inputs_2 + bias_h1_0);
            hidden1_1 = $tanh(weights_h1_3 * inputs_0 + weights_h1_4 * inputs_1 + weights_h1_5 * inputs_2 + bias_h1_1);
            hidden1_2 = $tanh(weights_h1_6 * inputs_0 + weights_h1_7 * inputs_1 + weights_h1_8 * inputs_2 + bias_h1_2);
            hidden1_3 = $tanh(weights_h1_9 * inputs_0 + weights_h1_10 * inputs_1 + weights_h1_11 * inputs_2 + bias_h1_3);
            hidden1_4 = $tanh(weights_h1_12 * inputs_0 + weights_h1_13 * inputs_1 + weights_h1_14 * inputs_2 + bias_h1_4);
            hidden1_5 = $tanh(weights_h1_15 * inputs_0 + weights_h1_16 * inputs_1 + weights_h1_17 * inputs_2 + bias_h1_5);
            hidden1_6 = $tanh(weights_h1_18 * inputs_0 + weights_h1_19 * inputs_1 + weights_h1_20 * inputs_2 + bias_h1_6);
            hidden1_7 = $tanh(weights_h1_21 * inputs_0 + weights_h1_22 * inputs_1 + weights_h1_23 * inputs_2 + bias_h1_7);
            hidden1_8 = $tanh(weights_h1_24 * inputs_0 + weights_h1_25 * inputs_1 + weights_h1_26 * inputs_2 + bias_h1_8);
            hidden1_9 = $tanh(weights_h1_27 * inputs_0 + weights_h1_28 * inputs_1 + weights_h1_29 * inputs_2 + bias_h1_9);
            hidden1_10 = $tanh(weights_h1_30 * inputs_0 + weights_h1_31 * inputs_1 + weights_h1_32 * inputs_2 + bias_h1_10);
            hidden1_11 = $tanh(weights_h1_33 * inputs_0 + weights_h1_34 * inputs_1 + weights_h1_35 * inputs_2 + bias_h1_11);
            hidden1_12 = $tanh(weights_h1_36 * inputs_0 + weights_h1_37 * inputs_1 + weights_h1_38 * inputs_2 + bias_h1_12);
            hidden1_13 = $tanh(weights_h1_39 * inputs_0 + weights_h1_40 * inputs_1 + weights_h1_41 * inputs_2 + bias_h1_13);
            hidden1_14 = $tanh(weights_h1_42 * inputs_0 + weights_h1_43 * inputs_1 + weights_h1_44 * inputs_2 + bias_h1_14);
            hidden1_15 = $tanh(weights_h1_45 * inputs_0 + weights_h1_46 * inputs_1 + weights_h1_47 * inputs_2 + bias_h1_15);
            hidden1_16 = $tanh(weights_h1_48 * inputs_0 + weights_h1_49 * inputs_1 + weights_h1_50 * inputs_2 + bias_h1_16);
            hidden1_17 = $tanh(weights_h1_51 * inputs_0 + weights_h1_52 * inputs_1 + weights_h1_53 * inputs_2 + bias_h1_17);
            hidden1_18 = $tanh(weights_h1_54 * inputs_0 + weights_h1_55 * inputs_1 + weights_h1_56 * inputs_2 + bias_h1_18);
            hidden1_19 = $tanh(weights_h1_57 * inputs_0 + weights_h1_58 * inputs_1 + weights_h1_59 * inputs_2 + bias_h1_19);
            hidden1_20 = $tanh(weights_h1_60 * inputs_0 + weights_h1_61 * inputs_1 + weights_h1_62 * inputs_2 + bias_h1_20);
            hidden1_21 = $tanh(weights_h1_63 * inputs_0 + weights_h1_64 * inputs_1 + weights_h1_65 * inputs_2 + bias_h1_21);
            hidden1_22 = $tanh(weights_h1_66 * inputs_0 + weights_h1_67 * inputs_1 + weights_h1_68 * inputs_2 + bias_h1_22);
            hidden1_23 = $tanh(weights_h1_69 * inputs_0 + weights_h1_70 * inputs_1 + weights_h1_71 * inputs_2 + bias_h1_23);
            hidden1_24 = $tanh(weights_h1_72 * inputs_0 + weights_h1_73 * inputs_1 + weights_h1_74 * inputs_2 + bias_h1_24);
            hidden1_25 = $tanh(weights_h1_75 * inputs_0 + weights_h1_76 * inputs_1 + weights_h1_77 * inputs_2 + bias_h1_25);
            hidden1_26 = $tanh(weights_h1_78 * inputs_0 + weights_h1_79 * inputs_1 + weights_h1_80 * inputs_2 + bias_h1_26);
            hidden1_27 = $tanh(weights_h1_81 * inputs_0 + weights_h1_82 * inputs_1 + weights_h1_83 * inputs_2 + bias_h1_27);
            hidden1_28 = $tanh(weights_h1_84 * inputs_0 + weights_h1_85 * inputs_1 + weights_h1_86 * inputs_2 + bias_h1_28);
            hidden1_29 = $tanh(weights_h1_87 * inputs_0 + weights_h1_88 * inputs_1 + weights_h1_89 * inputs_2 + bias_h1_29);
            hidden1_30 = $tanh(weights_h1_90 * inputs_0 + weights_h1_91 * inputs_1 + weights_h1_92 * inputs_2 + bias_h1_30);
            hidden1_31 = $tanh(weights_h1_93 * inputs_0 + weights_h1_94 * inputs_1 + weights_h1_95 * inputs_2 + bias_h1_31);

            // Second hidden layer (64 neurons)
            hidden2_0 = $tanh(weights_h2_0 * hidden1_0 + weights_h2_1 * hidden1_1 + weights_h2_2 * hidden1_2 + weights_h2_3 * hidden1_3 + weights_h2_4 * hidden1_4 + weights_h2_5 * hidden1_5 + weights_h2_6 * hidden1_6 + weights_h2_7 * hidden1_7 + weights_h2_8 * hidden1_8 + weights_h2_9 * hidden1_9 + weights_h2_10 * hidden1_10 + weights_h2_11 * hidden1_11 + weights_h2_12 * hidden1_12 + weights_h2_13 * hidden1_13 + weights_h2_14 * hidden1_14 + weights_h2_15 * hidden1_15 + weights_h2_16 * hidden1_16 + weights_h2_17 * hidden1_17 + weights_h2_18 * hidden1_18 + weights_h2_19 * hidden1_19 + weights_h2_20 * hidden1_20 + weights_h2_21 * hidden1_21 + weights_h2_22 * hidden1_22 + weights_h2_23 * hidden1_23 + weights_h2_24 * hidden1_24 + weights_h2_25 * hidden1_25 + weights_h2_26 * hidden1_26 + weights_h2_27 * hidden1_27 + weights_h2_28 * hidden1_28 + weights_h2_29 * hidden1_29 + weights_h2_30 * hidden1_30 + weights_h2_31 * hidden1_31 + bias_h2_0);
            hidden2_1 = $tanh(weights_h2_32 * hidden1_0 + weights_h2_33 * hidden1_1 + weights_h2_34 * hidden1_2 + weights_h2_35 * hidden1_3 + weights_h2_36 * hidden1_4 + weights_h2_37 * hidden1_5 + weights_h2_38 * hidden1_6 + weights_h2_39 * hidden1_7 + weights_h2_40 * hidden1_8 + weights_h2_41 * hidden1_9 + weights_h2_42 * hidden1_10 + weights_h2_43 * hidden1_11 + weights_h2_44 * hidden1_12 + weights_h2_45 * hidden1_13 + weights_h2_46 * hidden1_14 + weights_h2_47 * hidden1_15 + weights_h2_48 * hidden1_16 + weights_h2_49 * hidden1_17 + weights_h2_50 * hidden1_18 + weights_h2_51 * hidden1_19 + weights_h2_52 * hidden1_20 + weights_h2_53 * hidden1_21 + weights_h2_54 * hidden1_22 + weights_h2_55 * hidden1_23 + weights_h2_56 * hidden1_24 + weights_h2_57 * hidden1_25 + weights_h2_58 * hidden1_26 + weights_h2_59 * hidden1_27 + weights_h2_60 * hidden1_28 + weights_h2_61 * hidden1_29 + weights_h2_62 * hidden1_30 + weights_h2_63 * hidden1_31 + bias_h2_1);
            hidden2_2 = $tanh(weights_h2_64 * hidden1_0 + weights_h2_65 * hidden1_1 + weights_h2_66 * hidden1_2 + weights_h2_67 * hidden1_3 + weights_h2_68 * hidden1_4 + weights_h2_69 * hidden1_5 + weights_h2_70 * hidden1_6 + weights_h2_71 * hidden1_7 + weights_h2_72 * hidden1_8 + weights_h2_73 * hidden1_9 + weights_h2_74 * hidden1_10 + weights_h2_75 * hidden1_11 + weights_h2_76 * hidden1_12 + weights_h2_77 * hidden1_13 + weights_h2_78 * hidden1_14 + weights_h2_79 * hidden1_15 + weights_h2_80 * hidden1_16 + weights_h2_81 * hidden1_17 + weights_h2_82 * hidden1_18 + weights_h2_83 * hidden1_19 + weights_h2_84 * hidden1_20 + weights_h2_85 * hidden1_21 + weights_h2_86 * hidden1_22 + weights_h2_87 * hidden1_23 + weights_h2_88 * hidden1_24 + weights_h2_89 * hidden1_25 + weights_h2_90 * hidden1_26 + weights_h2_91 * hidden1_27 + weights_h2_92 * hidden1_28 + weights_h2_93 * hidden1_29 + weights_h2_94 * hidden1_30 + weights_h2_95 * hidden1_31 + bias_h2_2);
            hidden2_3 = $tanh(weights_h2_96 * hidden1_0 + weights_h2_97 * hidden1_1 + weights_h2_98 * hidden1_2 + weights_h2_99 * hidden1_3 + weights_h2_100 * hidden1_4 + weights_h2_101 * hidden1_5 + weights_h2_102 * hidden1_6 + weights_h2_103 * hidden1_7 + weights_h2_104 * hidden1_8 + weights_h2_105 * hidden1_9 + weights_h2_106 * hidden1_10 + weights_h2_107 * hidden1_11 + weights_h2_108 * hidden1_12 + weights_h2_109 * hidden1_13 + weights_h2_110 * hidden1_14 + weights_h2_111 * hidden1_15 + weights_h2_112 * hidden1_16 + weights_h2_113 * hidden1_17 + weights_h2_114 * hidden1_18 + weights_h2_115 * hidden1_19 + weights_h2_116 * hidden1_20 + weights_h2_117 * hidden1_21 + weights_h2_118 * hidden1_22 + weights_h2_119 * hidden1_23 + weights_h2_120 * hidden1_24 + weights_h2_121 * hidden1_25 + weights_h2_122 * hidden1_26 + weights_h2_123 * hidden1_27 + weights_h2_124 * hidden1_28 + weights_h2_125 * hidden1_29 + weights_h2_126 * hidden1_30 + weights_h2_127 * hidden1_31 + bias_h2_3);
            hidden2_4 = $tanh(weights_h2_128 * hidden1_0 + weights_h2_129 * hidden1_1 + weights_h2_130 * hidden1_2 + weights_h2_131 * hidden1_3 + weights_h2_132 * hidden1_4 + weights_h2_133 * hidden1_5 + weights_h2_134 * hidden1_6 + weights_h2_135 * hidden1_7 + weights_h2_136 * hidden1_8 + weights_h2_137 * hidden1_9 + weights_h2_138 * hidden1_10 + weights_h2_139 * hidden1_11 + weights_h2_140 * hidden1_12 + weights_h2_141 * hidden1_13 + weights_h2_142 * hidden1_14 + weights_h2_143 * hidden1_15 + weights_h2_144 * hidden1_16 + weights_h2_145 * hidden1_17 + weights_h2_146 * hidden1_18 + weights_h2_147 * hidden1_19 + weights_h2_148 * hidden1_20 + weights_h2_149 * hidden1_21 + weights_h2_150 * hidden1_22 + weights_h2_151 * hidden1_23 + weights_h2_152 * hidden1_24 + weights_h2_153 * hidden1_25 + weights_h2_154 * hidden1_26 + weights_h2_155 * hidden1_27 + weights_h2_156 * hidden1_28 + weights_h2_157 * hidden1_29 + weights_h2_158 * hidden1_30 + weights_h2_159 * hidden1_31 + bias_h2_4);
            hidden2_5 = $tanh(weights_h2_160 * hidden1_0 + weights_h2_161 * hidden1_1 + weights_h2_162 * hidden1_2 + weights_h2_163 * hidden1_3 + weights_h2_164 * hidden1_4 + weights_h2_165 * hidden1_5 + weights_h2_166 * hidden1_6 + weights_h2_167 * hidden1_7 + weights_h2_168 * hidden1_8 + weights_h2_169 * hidden1_9 + weights_h2_170 * hidden1_10 + weights_h2_171 * hidden1_11 + weights_h2_172 * hidden1_12 + weights_h2_173 * hidden1_13 + weights_h2_174 * hidden1_14 + weights_h2_175 * hidden1_15 + weights_h2_176 * hidden1_16 + weights_h2_177 * hidden1_17 + weights_h2_178 * hidden1_18 + weights_h2_179 * hidden1_19 + weights_h2_180 * hidden1_20 + weights_h2_181 * hidden1_21 + weights_h2_182 * hidden1_22 + weights_h2_183 * hidden1_23 + weights_h2_184 * hidden1_24 + weights_h2_185 * hidden1_25 + weights_h2_186 * hidden1_26 + weights_h2_187 * hidden1_27 + weights_h2_188 * hidden1_28 + weights_h2_189 * hidden1_29 + weights_h2_190 * hidden1_30 + weights_h2_191 * hidden1_31 + bias_h2_5);
            hidden2_6 = $tanh(weights_h2_192 * hidden1_0 + weights_h2_193 * hidden1_1 + weights_h2_194 * hidden1_2 + weights_h2_195 * hidden1_3 + weights_h2_196 * hidden1_4 + weights_h2_197 * hidden1_5 + weights_h2_198 * hidden1_6 + weights_h2_199 * hidden1_7 + weights_h2_200 * hidden1_8 + weights_h2_201 * hidden1_9 + weights_h2_202 * hidden1_10 + weights_h2_203 * hidden1_11 + weights_h2_204 * hidden1_12 + weights_h2_205 * hidden1_13 + weights_h2_206 * hidden1_14 + weights_h2_207 * hidden1_15 + weights_h2_208 * hidden1_16 + weights_h2_209 * hidden1_17 + weights_h2_210 * hidden1_18 + weights_h2_211 * hidden1_19 + weights_h2_212 * hidden1_20 + weights_h2_213 * hidden1_21 + weights_h2_214 * hidden1_22 + weights_h2_215 * hidden1_23 + weights_h2_216 * hidden1_24 + weights_h2_217 * hidden1_25 + weights_h2_218 * hidden1_26 + weights_h2_219 * hidden1_27 + weights_h2_220 * hidden1_28 + weights_h2_221 * hidden1_29 + weights_h2_222 * hidden1_30 + weights_h2_223 * hidden1_31 + bias_h2_6);
            hidden2_7 = $tanh(weights_h2_224 * hidden1_0 + weights_h2_225 * hidden1_1 + weights_h2_226 * hidden1_2 + weights_h2_227 * hidden1_3 + weights_h2_228 * hidden1_4 + weights_h2_229 * hidden1_5 + weights_h2_230 * hidden1_6 + weights_h2_231 * hidden1_7 + weights_h2_232 * hidden1_8 + weights_h2_233 * hidden1_9 + weights_h2_234 * hidden1_10 + weights_h2_235 * hidden1_11 + weights_h2_236 * hidden1_12 + weights_h2_237 * hidden1_13 + weights_h2_238 * hidden1_14 + weights_h2_239 * hidden1_15 + weights_h2_240 * hidden1_16 + weights_h2_241 * hidden1_17 + weights_h2_242 * hidden1_18 + weights_h2_243 * hidden1_19 + weights_h2_244 * hidden1_20 + weights_h2_245 * hidden1_21 + weights_h2_246 * hidden1_22 + weights_h2_247 * hidden1_23 + weights_h2_248 * hidden1_24 + weights_h2_249 * hidden1_25 + weights_h2_250 * hidden1_26 + weights_h2_251 * hidden1_27 + weights_h2_252 * hidden1_28 + weights_h2_253 * hidden1_29 + weights_h2_254 * hidden1_30 + weights_h2_255 * hidden1_31 + bias_h2_7);
            hidden2_8 = $tanh(weights_h2_256 * hidden1_0 + weights_h2_257 * hidden1_1 + weights_h2_258 * hidden1_2 + weights_h2_259 * hidden1_3 + weights_h2_260 * hidden1_4 + weights_h2_261 * hidden1_5 + weights_h2_262 * hidden1_6 + weights_h2_263 * hidden1_7 + weights_h2_264 * hidden1_8 + weights_h2_265 * hidden1_9 + weights_h2_266 * hidden1_10 + weights_h2_267 * hidden1_11 + weights_h2_268 * hidden1_12 + weights_h2_269 * hidden1_13 + weights_h2_270 * hidden1_14 + weights_h2_271 * hidden1_15 + weights_h2_272 * hidden1_16 + weights_h2_273 * hidden1_17 + weights_h2_274 * hidden1_18 + weights_h2_275 * hidden1_19 + weights_h2_276 * hidden1_20 + weights_h2_277 * hidden1_21 + weights_h2_278 * hidden1_22 + weights_h2_279 * hidden1_23 + weights_h2_280 * hidden1_24 + weights_h2_281 * hidden1_25 + weights_h2_282 * hidden1_26 + weights_h2_283 * hidden1_27 + weights_h2_284 * hidden1_28 + weights_h2_285 * hidden1_29 + weights_h2_286 * hidden1_30 + weights_h2_287 * hidden1_31 + bias_h2_8);
            hidden2_9 = $tanh(weights_h2_288 * hidden1_0 + weights_h2_289 * hidden1_1 + weights_h2_290 * hidden1_2 + weights_h2_291 * hidden1_3 + weights_h2_292 * hidden1_4 + weights_h2_293 * hidden1_5 + weights_h2_294 * hidden1_6 + weights_h2_295 * hidden1_7 + weights_h2_296 * hidden1_8 + weights_h2_297 * hidden1_9 + weights_h2_298 * hidden1_10 + weights_h2_299 * hidden1_11 + weights_h2_300 * hidden1_12 + weights_h2_301 * hidden1_13 + weights_h2_302 * hidden1_14 + weights_h2_303 * hidden1_15 + weights_h2_304 * hidden1_16 + weights_h2_305 * hidden1_17 + weights_h2_306 * hidden1_18 + weights_h2_307 * hidden1_19 + weights_h2_308 * hidden1_20 + weights_h2_309 * hidden1_21 + weights_h2_310 * hidden1_22 + weights_h2_311 * hidden1_23 + weights_h2_312 * hidden1_24 + weights_h2_313 * hidden1_25 + weights_h2_314 * hidden1_26 + weights_h2_315 * hidden1_27 + weights_h2_316 * hidden1_28 + weights_h2_317 * hidden1_29 + weights_h2_318 * hidden1_30 + weights_h2_319 * hidden1_31 + bias_h2_9);
            hidden2_10 = $tanh(weights_h2_320 * hidden1_0 + weights_h2_321 * hidden1_1 + weights_h2_322 * hidden1_2 + weights_h2_323 * hidden1_3 + weights_h2_324 * hidden1_4 + weights_h2_325 * hidden1_5 + weights_h2_326 * hidden1_6 + weights_h2_327 * hidden1_7 + weights_h2_328 * hidden1_8 + weights_h2_329 * hidden1_9 + weights_h2_330 * hidden1_10 + weights_h2_331 * hidden1_11 + weights_h2_332 * hidden1_12 + weights_h2_333 * hidden1_13 + weights_h2_334 * hidden1_14 + weights_h2_335 * hidden1_15 + weights_h2_336 * hidden1_16 + weights_h2_337 * hidden1_17 + weights_h2_338 * hidden1_18 + weights_h2_339 * hidden1_19 + weights_h2_340 * hidden1_20 + weights_h2_341 * hidden1_21 + weights_h2_342 * hidden1_22 + weights_h2_343 * hidden1_23 + weights_h2_344 * hidden1_24 + weights_h2_345 * hidden1_25 + weights_h2_346 * hidden1_26 + weights_h2_347 * hidden1_27 + weights_h2_348 * hidden1_28 + weights_h2_349 * hidden1_29 + weights_h2_350 * hidden1_30 + weights_h2_351 * hidden1_31 + bias_h2_10);
            hidden2_11 = $tanh(weights_h2_352 * hidden1_0 + weights_h2_353 * hidden1_1 + weights_h2_354 * hidden1_2 + weights_h2_355 * hidden1_3 + weights_h2_356 * hidden1_4 + weights_h2_357 * hidden1_5 + weights_h2_358 * hidden1_6 + weights_h2_359 * hidden1_7 + weights_h2_360 * hidden1_8 + weights_h2_361 * hidden1_9 + weights_h2_362 * hidden1_10 + weights_h2_363 * hidden1_11 + weights_h2_364 * hidden1_12 + weights_h2_365 * hidden1_13 + weights_h2_366 * hidden1_14 + weights_h2_367 * hidden1_15 + weights_h2_368 * hidden1_16 + weights_h2_369 * hidden1_17 + weights_h2_370 * hidden1_18 + weights_h2_371 * hidden1_19 + weights_h2_372 * hidden1_20 + weights_h2_373 * hidden1_21 + weights_h2_374 * hidden1_22 + weights_h2_375 * hidden1_23 + weights_h2_376 * hidden1_24 + weights_h2_377 * hidden1_25 + weights_h2_378 * hidden1_26 + weights_h2_379 * hidden1_27 + weights_h2_380 * hidden1_28 + weights_h2_381 * hidden1_29 + weights_h2_382 * hidden1_30 + weights_h2_383 * hidden1_31 + bias_h2_11);
            hidden2_12 = $tanh(weights_h2_384 * hidden1_0 + weights_h2_385 * hidden1_1 + weights_h2_386 * hidden1_2 + weights_h2_387 * hidden1_3 + weights_h2_388 * hidden1_4 + weights_h2_389 * hidden1_5 + weights_h2_390 * hidden1_6 + weights_h2_391 * hidden1_7 + weights_h2_392 * hidden1_8 + weights_h2_393 * hidden1_9 + weights_h2_394 * hidden1_10 + weights_h2_395 * hidden1_11 + weights_h2_396 * hidden1_12 + weights_h2_397 * hidden1_13 + weights_h2_398 * hidden1_14 + weights_h2_399 * hidden1_15 + weights_h2_400 * hidden1_16 + weights_h2_401 * hidden1_17 + weights_h2_402 * hidden1_18 + weights_h2_403 * hidden1_19 + weights_h2_404 * hidden1_20 + weights_h2_405 * hidden1_21 + weights_h2_406 * hidden1_22 + weights_h2_407 * hidden1_23 + weights_h2_408 * hidden1_24 + weights_h2_409 * hidden1_25 + weights_h2_410 * hidden1_26 + weights_h2_411 * hidden1_27 + weights_h2_412 * hidden1_28 + weights_h2_413 * hidden1_29 + weights_h2_414 * hidden1_30 + weights_h2_415 * hidden1_31 + bias_h2_12);
            hidden2_13 = $tanh(weights_h2_416 * hidden1_0 + weights_h2_417 * hidden1_1 + weights_h2_418 * hidden1_2 + weights_h2_419 * hidden1_3 + weights_h2_420 * hidden1_4 + weights_h2_421 * hidden1_5 + weights_h2_422 * hidden1_6 + weights_h2_423 * hidden1_7 + weights_h2_424 * hidden1_8 + weights_h2_425 * hidden1_9 + weights_h2_426 * hidden1_10 + weights_h2_427 * hidden1_11 + weights_h2_428 * hidden1_12 + weights_h2_429 * hidden1_13 + weights_h2_430 * hidden1_14 + weights_h2_431 * hidden1_15 + weights_h2_432 * hidden1_16 + weights_h2_433 * hidden1_17 + weights_h2_434 * hidden1_18 + weights_h2_435 * hidden1_19 + weights_h2_436 * hidden1_20 + weights_h2_437 * hidden1_21 + weights_h2_438 * hidden1_22 + weights_h2_439 * hidden1_23 + weights_h2_440 * hidden1_24 + weights_h2_441 * hidden1_25 + weights_h2_442 * hidden1_26 + weights_h2_443 * hidden1_27 + weights_h2_444 * hidden1_28 + weights_h2_445 * hidden1_29 + weights_h2_446 * hidden1_30 + weights_h2_447 * hidden1_31 + bias_h2_13);
            hidden2_14 = $tanh(weights_h2_448 * hidden1_0 + weights_h2_449 * hidden1_1 + weights_h2_450 * hidden1_2 + weights_h2_451 * hidden1_3 + weights_h2_452 * hidden1_4 + weights_h2_453 * hidden1_5 + weights_h2_454 * hidden1_6 + weights_h2_455 * hidden1_7 + weights_h2_456 * hidden1_8 + weights_h2_457 * hidden1_9 + weights_h2_458 * hidden1_10 + weights_h2_459 * hidden1_11 + weights_h2_460 * hidden1_12 + weights_h2_461 * hidden1_13 + weights_h2_462 * hidden1_14 + weights_h2_463 * hidden1_15 + weights_h2_464 * hidden1_16 + weights_h2_465 * hidden1_17 + weights_h2_466 * hidden1_18 + weights_h2_467 * hidden1_19 + weights_h2_468 * hidden1_20 + weights_h2_469 * hidden1_21 + weights_h2_470 * hidden1_22 + weights_h2_471 * hidden1_23 + weights_h2_472 * hidden1_24 + weights_h2_473 * hidden1_25 + weights_h2_474 * hidden1_26 + weights_h2_475 * hidden1_27 + weights_h2_476 * hidden1_28 + weights_h2_477 * hidden1_29 + weights_h2_478 * hidden1_30 + weights_h2_479 * hidden1_31 + bias_h2_14);
            hidden2_15 = $tanh(weights_h2_480 * hidden1_0 + weights_h2_481 * hidden1_1 + weights_h2_482 * hidden1_2 + weights_h2_483 * hidden1_3 + weights_h2_484 * hidden1_4 + weights_h2_485 * hidden1_5 + weights_h2_486 * hidden1_6 + weights_h2_487 * hidden1_7 + weights_h2_488 * hidden1_8 + weights_h2_489 * hidden1_9 + weights_h2_490 * hidden1_10 + weights_h2_491 * hidden1_11 + weights_h2_492 * hidden1_12 + weights_h2_493 * hidden1_13 + weights_h2_494 * hidden1_14 + weights_h2_495 * hidden1_15 + weights_h2_496 * hidden1_16 + weights_h2_497 * hidden1_17 + weights_h2_498 * hidden1_18 + weights_h2_499 * hidden1_19 + weights_h2_500 * hidden1_20 + weights_h2_501 * hidden1_21 + weights_h2_502 * hidden1_22 + weights_h2_503 * hidden1_23 + weights_h2_504 * hidden1_24 + weights_h2_505 * hidden1_25 + weights_h2_506 * hidden1_26 + weights_h2_507 * hidden1_27 + weights_h2_508 * hidden1_28 + weights_h2_509 * hidden1_29 + weights_h2_510 * hidden1_30 + weights_h2_511 * hidden1_31 + bias_h2_15);
            hidden2_16 = $tanh(weights_h2_512 * hidden1_0 + weights_h2_513 * hidden1_1 + weights_h2_514 * hidden1_2 + weights_h2_515 * hidden1_3 + weights_h2_516 * hidden1_4 + weights_h2_517 * hidden1_5 + weights_h2_518 * hidden1_6 + weights_h2_519 * hidden1_7 + weights_h2_520 * hidden1_8 + weights_h2_521 * hidden1_9 + weights_h2_522 * hidden1_10 + weights_h2_523 * hidden1_11 + weights_h2_524 * hidden1_12 + weights_h2_525 * hidden1_13 + weights_h2_526 * hidden1_14 + weights_h2_527 * hidden1_15 + weights_h2_528 * hidden1_16 + weights_h2_529 * hidden1_17 + weights_h2_530 * hidden1_18 + weights_h2_531 * hidden1_19 + weights_h2_532 * hidden1_20 + weights_h2_533 * hidden1_21 + weights_h2_534 * hidden1_22 + weights_h2_535 * hidden1_23 + weights_h2_536 * hidden1_24 + weights_h2_537 * hidden1_25 + weights_h2_538 * hidden1_26 + weights_h2_539 * hidden1_27 + weights_h2_540 * hidden1_28 + weights_h2_541 * hidden1_29 + weights_h2_542 * hidden1_30 + weights_h2_543 * hidden1_31 + bias_h2_16);
            hidden2_17 = $tanh(weights_h2_544 * hidden1_0 + weights_h2_545 * hidden1_1 + weights_h2_546 * hidden1_2 + weights_h2_547 * hidden1_3 + weights_h2_548 * hidden1_4 + weights_h2_549 * hidden1_5 + weights_h2_550 * hidden1_6 + weights_h2_551 * hidden1_7 + weights_h2_552 * hidden1_8 + weights_h2_553 * hidden1_9 + weights_h2_554 * hidden1_10 + weights_h2_555 * hidden1_11 + weights_h2_556 * hidden1_12 + weights_h2_557 * hidden1_13 + weights_h2_558 * hidden1_14 + weights_h2_559 * hidden1_15 + weights_h2_560 * hidden1_16 + weights_h2_561 * hidden1_17 + weights_h2_562 * hidden1_18 + weights_h2_563 * hidden1_19 + weights_h2_564 * hidden1_20 + weights_h2_565 * hidden1_21 + weights_h2_566 * hidden1_22 + weights_h2_567 * hidden1_23 + weights_h2_568 * hidden1_24 + weights_h2_569 * hidden1_25 + weights_h2_570 * hidden1_26 + weights_h2_571 * hidden1_27 + weights_h2_572 * hidden1_28 + weights_h2_573 * hidden1_29 + weights_h2_574 * hidden1_30 + weights_h2_575 * hidden1_31 + bias_h2_17);
            hidden2_18 = $tanh(weights_h2_576 * hidden1_0 + weights_h2_577 * hidden1_1 + weights_h2_578 * hidden1_2 + weights_h2_579 * hidden1_3 + weights_h2_580 * hidden1_4 + weights_h2_581 * hidden1_5 + weights_h2_582 * hidden1_6 + weights_h2_583 * hidden1_7 + weights_h2_584 * hidden1_8 + weights_h2_585 * hidden1_9 + weights_h2_586 * hidden1_10 + weights_h2_587 * hidden1_11 + weights_h2_588 * hidden1_12 + weights_h2_589 * hidden1_13 + weights_h2_590 * hidden1_14 + weights_h2_591 * hidden1_15 + weights_h2_592 * hidden1_16 + weights_h2_593 * hidden1_17 + weights_h2_594 * hidden1_18 + weights_h2_595 * hidden1_19 + weights_h2_596 * hidden1_20 + weights_h2_597 * hidden1_21 + weights_h2_598 * hidden1_22 + weights_h2_599 * hidden1_23 + weights_h2_600 * hidden1_24 + weights_h2_601 * hidden1_25 + weights_h2_602 * hidden1_26 + weights_h2_603 * hidden1_27 + weights_h2_604 * hidden1_28 + weights_h2_605 * hidden1_29 + weights_h2_606 * hidden1_30 + weights_h2_607 * hidden1_31 + bias_h2_18);
            hidden2_19 = $tanh(weights_h2_608 * hidden1_0 + weights_h2_609 * hidden1_1 + weights_h2_610 * hidden1_2 + weights_h2_611 * hidden1_3 + weights_h2_612 * hidden1_4 + weights_h2_613 * hidden1_5 + weights_h2_614 * hidden1_6 + weights_h2_615 * hidden1_7 + weights_h2_616 * hidden1_8 + weights_h2_617 * hidden1_9 + weights_h2_618 * hidden1_10 + weights_h2_619 * hidden1_11 + weights_h2_620 * hidden1_12 + weights_h2_621 * hidden1_13 + weights_h2_622 * hidden1_14 + weights_h2_623 * hidden1_15 + weights_h2_624 * hidden1_16 + weights_h2_625 * hidden1_17 + weights_h2_626 * hidden1_18 + weights_h2_627 * hidden1_19 + weights_h2_628 * hidden1_20 + weights_h2_629 * hidden1_21 + weights_h2_630 * hidden1_22 + weights_h2_631 * hidden1_23 + weights_h2_632 * hidden1_24 + weights_h2_633 * hidden1_25 + weights_h2_634 * hidden1_26 + weights_h2_635 * hidden1_27 + weights_h2_636 * hidden1_28 + weights_h2_637 * hidden1_29 + weights_h2_638 * hidden1_30 + weights_h2_639 * hidden1_31 + bias_h2_19);
            hidden2_20 = $tanh(weights_h2_640 * hidden1_0 + weights_h2_641 * hidden1_1 + weights_h2_642 * hidden1_2 + weights_h2_643 * hidden1_3 + weights_h2_644 * hidden1_4 + weights_h2_645 * hidden1_5 + weights_h2_646 * hidden1_6 + weights_h2_647 * hidden1_7 + weights_h2_648 * hidden1_8 + weights_h2_649 * hidden1_9 + weights_h2_650 * hidden1_10 + weights_h2_651 * hidden1_11 + weights_h2_652 * hidden1_12 + weights_h2_653 * hidden1_13 + weights_h2_654 * hidden1_14 + weights_h2_655 * hidden1_15 + weights_h2_656 * hidden1_16 + weights_h2_657 * hidden1_17 + weights_h2_658 * hidden1_18 + weights_h2_659 * hidden1_19 + weights_h2_660 * hidden1_20 + weights_h2_661 * hidden1_21 + weights_h2_662 * hidden1_22 + weights_h2_663 * hidden1_23 + weights_h2_664 * hidden1_24 + weights_h2_665 * hidden1_25 + weights_h2_666 * hidden1_26 + weights_h2_667 * hidden1_27 + weights_h2_668 * hidden1_28 + weights_h2_669 * hidden1_29 + weights_h2_670 * hidden1_30 + weights_h2_671 * hidden1_31 + bias_h2_20);
            hidden2_21 = $tanh(weights_h2_672 * hidden1_0 + weights_h2_673 * hidden1_1 + weights_h2_674 * hidden1_2 + weights_h2_675 * hidden1_3 + weights_h2_676 * hidden1_4 + weights_h2_677 * hidden1_5 + weights_h2_678 * hidden1_6 + weights_h2_679 * hidden1_7 + weights_h2_680 * hidden1_8 + weights_h2_681 * hidden1_9 + weights_h2_682 * hidden1_10 + weights_h2_683 * hidden1_11 + weights_h2_684 * hidden1_12 + weights_h2_685 * hidden1_13 + weights_h2_686 * hidden1_14 + weights_h2_687 * hidden1_15 + weights_h2_688 * hidden1_16 + weights_h2_689 * hidden1_17 + weights_h2_690 * hidden1_18 + weights_h2_691 * hidden1_19 + weights_h2_692 * hidden1_20 + weights_h2_693 * hidden1_21 + weights_h2_694 * hidden1_22 + weights_h2_695 * hidden1_23 + weights_h2_696 * hidden1_24 + weights_h2_697 * hidden1_25 + weights_h2_698 * hidden1_26 + weights_h2_699 * hidden1_27 + weights_h2_700 * hidden1_28 + weights_h2_701 * hidden1_29 + weights_h2_702 * hidden1_30 + weights_h2_703 * hidden1_31 + bias_h2_21);
            hidden2_22 = $tanh(weights_h2_704 * hidden1_0 + weights_h2_705 * hidden1_1 + weights_h2_706 * hidden1_2 + weights_h2_707 * hidden1_3 + weights_h2_708 * hidden1_4 + weights_h2_709 * hidden1_5 + weights_h2_710 * hidden1_6 + weights_h2_711 * hidden1_7 + weights_h2_712 * hidden1_8 + weights_h2_713 * hidden1_9 + weights_h2_714 * hidden1_10 + weights_h2_715 * hidden1_11 + weights_h2_716 * hidden1_12 + weights_h2_717 * hidden1_13 + weights_h2_718 * hidden1_14 + weights_h2_719 * hidden1_15 + weights_h2_720 * hidden1_16 + weights_h2_721 * hidden1_17 + weights_h2_722 * hidden1_18 + weights_h2_723 * hidden1_19 + weights_h2_724 * hidden1_20 + weights_h2_725 * hidden1_21 + weights_h2_726 * hidden1_22 + weights_h2_727 * hidden1_23 + weights_h2_728 * hidden1_24 + weights_h2_729 * hidden1_25 + weights_h2_730 * hidden1_26 + weights_h2_731 * hidden1_27 + weights_h2_732 * hidden1_28 + weights_h2_733 * hidden1_29 + weights_h2_734 * hidden1_30 + weights_h2_735 * hidden1_31 + bias_h2_22);
            hidden2_23 = $tanh(weights_h2_736 * hidden1_0 + weights_h2_737 * hidden1_1 + weights_h2_738 * hidden1_2 + weights_h2_739 * hidden1_3 + weights_h2_740 * hidden1_4 + weights_h2_741 * hidden1_5 + weights_h2_742 * hidden1_6 + weights_h2_743 * hidden1_7 + weights_h2_744 * hidden1_8 + weights_h2_745 * hidden1_9 + weights_h2_746 * hidden1_10 + weights_h2_747 * hidden1_11 + weights_h2_748 * hidden1_12 + weights_h2_749 * hidden1_13 + weights_h2_750 * hidden1_14 + weights_h2_751 * hidden1_15 + weights_h2_752 * hidden1_16 + weights_h2_753 * hidden1_17 + weights_h2_754 * hidden1_18 + weights_h2_755 * hidden1_19 + weights_h2_756 * hidden1_20 + weights_h2_757 * hidden1_21 + weights_h2_758 * hidden1_22 + weights_h2_759 * hidden1_23 + weights_h2_760 * hidden1_24 + weights_h2_761 * hidden1_25 + weights_h2_762 * hidden1_26 + weights_h2_763 * hidden1_27 + weights_h2_764 * hidden1_28 + weights_h2_765 * hidden1_29 + weights_h2_766 * hidden1_30 + weights_h2_767 * hidden1_31 + bias_h2_23);
            hidden2_24 = $tanh(weights_h2_768 * hidden1_0 + weights_h2_769 * hidden1_1 + weights_h2_770 * hidden1_2 + weights_h2_771 * hidden1_3 + weights_h2_772 * hidden1_4 + weights_h2_773 * hidden1_5 + weights_h2_774 * hidden1_6 + weights_h2_775 * hidden1_7 + weights_h2_776 * hidden1_8 + weights_h2_777 * hidden1_9 + weights_h2_778 * hidden1_10 + weights_h2_779 * hidden1_11 + weights_h2_780 * hidden1_12 + weights_h2_781 * hidden1_13 + weights_h2_782 * hidden1_14 + weights_h2_783 * hidden1_15 + weights_h2_784 * hidden1_16 + weights_h2_785 * hidden1_17 + weights_h2_786 * hidden1_18 + weights_h2_787 * hidden1_19 + weights_h2_788 * hidden1_20 + weights_h2_789 * hidden1_21 + weights_h2_790 * hidden1_22 + weights_h2_791 * hidden1_23 + weights_h2_792 * hidden1_24 + weights_h2_793 * hidden1_25 + weights_h2_794 * hidden1_26 + weights_h2_795 * hidden1_27 + weights_h2_796 * hidden1_28 + weights_h2_797 * hidden1_29 + weights_h2_798 * hidden1_30 + weights_h2_799 * hidden1_31 + bias_h2_24);
            hidden2_25 = $tanh(weights_h2_800 * hidden1_0 + weights_h2_801 * hidden1_1 + weights_h2_802 * hidden1_2 + weights_h2_803 * hidden1_3 + weights_h2_804 * hidden1_4 + weights_h2_805 * hidden1_5 + weights_h2_806 * hidden1_6 + weights_h2_807 * hidden1_7 + weights_h2_808 * hidden1_8 + weights_h2_809 * hidden1_9 + weights_h2_810 * hidden1_10 + weights_h2_811 * hidden1_11 + weights_h2_812 * hidden1_12 + weights_h2_813 * hidden1_13 + weights_h2_814 * hidden1_14 + weights_h2_815 * hidden1_15 + weights_h2_816 * hidden1_16 + weights_h2_817 * hidden1_17 + weights_h2_818 * hidden1_18 + weights_h2_819 * hidden1_19 + weights_h2_820 * hidden1_20 + weights_h2_821 * hidden1_21 + weights_h2_822 * hidden1_22 + weights_h2_823 * hidden1_23 + weights_h2_824 * hidden1_24 + weights_h2_825 * hidden1_25 + weights_h2_826 * hidden1_26 + weights_h2_827 * hidden1_27 + weights_h2_828 * hidden1_28 + weights_h2_829 * hidden1_29 + weights_h2_830 * hidden1_30 + weights_h2_831 * hidden1_31 + bias_h2_25);
            hidden2_26 = $tanh(weights_h2_832 * hidden1_0 + weights_h2_833 * hidden1_1 + weights_h2_834 * hidden1_2 + weights_h2_835 * hidden1_3 + weights_h2_836 * hidden1_4 + weights_h2_837 * hidden1_5 + weights_h2_838 * hidden1_6 + weights_h2_839 * hidden1_7 + weights_h2_840 * hidden1_8 + weights_h2_841 * hidden1_9 + weights_h2_842 * hidden1_10 + weights_h2_843 * hidden1_11 + weights_h2_844 * hidden1_12 + weights_h2_845 * hidden1_13 + weights_h2_846 * hidden1_14 + weights_h2_847 * hidden1_15 + weights_h2_848 * hidden1_16 + weights_h2_849 * hidden1_17 + weights_h2_850 * hidden1_18 + weights_h2_851 * hidden1_19 + weights_h2_852 * hidden1_20 + weights_h2_853 * hidden1_21 + weights_h2_854 * hidden1_22 + weights_h2_855 * hidden1_23 + weights_h2_856 * hidden1_24 + weights_h2_857 * hidden1_25 + weights_h2_858 * hidden1_26 + weights_h2_859 * hidden1_27 + weights_h2_860 * hidden1_28 + weights_h2_861 * hidden1_29 + weights_h2_862 * hidden1_30 + weights_h2_863 * hidden1_31 + bias_h2_26);
            hidden2_27 = $tanh(weights_h2_864 * hidden1_0 + weights_h2_865 * hidden1_1 + weights_h2_866 * hidden1_2 + weights_h2_867 * hidden1_3 + weights_h2_868 * hidden1_4 + weights_h2_869 * hidden1_5 + weights_h2_870 * hidden1_6 + weights_h2_871 * hidden1_7 + weights_h2_872 * hidden1_8 + weights_h2_873 * hidden1_9 + weights_h2_874 * hidden1_10 + weights_h2_875 * hidden1_11 + weights_h2_876 * hidden1_12 + weights_h2_877 * hidden1_13 + weights_h2_878 * hidden1_14 + weights_h2_879 * hidden1_15 + weights_h2_880 * hidden1_16 + weights_h2_881 * hidden1_17 + weights_h2_882 * hidden1_18 + weights_h2_883 * hidden1_19 + weights_h2_884 * hidden1_20 + weights_h2_885 * hidden1_21 + weights_h2_886 * hidden1_22 + weights_h2_887 * hidden1_23 + weights_h2_888 * hidden1_24 + weights_h2_889 * hidden1_25 + weights_h2_890 * hidden1_26 + weights_h2_891 * hidden1_27 + weights_h2_892 * hidden1_28 + weights_h2_893 * hidden1_29 + weights_h2_894 * hidden1_30 + weights_h2_895 * hidden1_31 + bias_h2_27);
            hidden2_28 = $tanh(weights_h2_896 * hidden1_0 + weights_h2_897 * hidden1_1 + weights_h2_898 * hidden1_2 + weights_h2_899 * hidden1_3 + weights_h2_900 * hidden1_4 + weights_h2_901 * hidden1_5 + weights_h2_902 * hidden1_6 + weights_h2_903 * hidden1_7 + weights_h2_904 * hidden1_8 + weights_h2_905 * hidden1_9 + weights_h2_906 * hidden1_10 + weights_h2_907 * hidden1_11 + weights_h2_908 * hidden1_12 + weights_h2_909 * hidden1_13 + weights_h2_910 * hidden1_14 + weights_h2_911 * hidden1_15 + weights_h2_912 * hidden1_16 + weights_h2_913 * hidden1_17 + weights_h2_914 * hidden1_18 + weights_h2_915 * hidden1_19 + weights_h2_916 * hidden1_20 + weights_h2_917 * hidden1_21 + weights_h2_918 * hidden1_22 + weights_h2_919 * hidden1_23 + weights_h2_920 * hidden1_24 + weights_h2_921 * hidden1_25 + weights_h2_922 * hidden1_26 + weights_h2_923 * hidden1_27 + weights_h2_924 * hidden1_28 + weights_h2_925 * hidden1_29 + weights_h2_926 * hidden1_30 + weights_h2_927 * hidden1_31 + bias_h2_28);
            hidden2_29 = $tanh(weights_h2_928 * hidden1_0 + weights_h2_929 * hidden1_1 + weights_h2_930 * hidden1_2 + weights_h2_931 * hidden1_3 + weights_h2_932 * hidden1_4 + weights_h2_933 * hidden1_5 + weights_h2_934 * hidden1_6 + weights_h2_935 * hidden1_7 + weights_h2_936 * hidden1_8 + weights_h2_937 * hidden1_9 + weights_h2_938 * hidden1_10 + weights_h2_939 * hidden1_11 + weights_h2_940 * hidden1_12 + weights_h2_941 * hidden1_13 + weights_h2_942 * hidden1_14 + weights_h2_943 * hidden1_15 + weights_h2_944 * hidden1_16 + weights_h2_945 * hidden1_17 + weights_h2_946 * hidden1_18 + weights_h2_947 * hidden1_19 + weights_h2_948 * hidden1_20 + weights_h2_949 * hidden1_21 + weights_h2_950 * hidden1_22 + weights_h2_951 * hidden1_23 + weights_h2_952 * hidden1_24 + weights_h2_953 * hidden1_25 + weights_h2_954 * hidden1_26 + weights_h2_955 * hidden1_27 + weights_h2_956 * hidden1_28 + weights_h2_957 * hidden1_29 + weights_h2_958 * hidden1_30 + weights_h2_959 * hidden1_31 + bias_h2_29);
            hidden2_30 = $tanh(weights_h2_960 * hidden1_0 + weights_h2_961 * hidden1_1 + weights_h2_962 * hidden1_2 + weights_h2_963 * hidden1_3 + weights_h2_964 * hidden1_4 + weights_h2_965 * hidden1_5 + weights_h2_966 * hidden1_6 + weights_h2_967 * hidden1_7 + weights_h2_968 * hidden1_8 + weights_h2_969 * hidden1_9 + weights_h2_970 * hidden1_10 + weights_h2_971 * hidden1_11 + weights_h2_972 * hidden1_12 + weights_h2_973 * hidden1_13 + weights_h2_974 * hidden1_14 + weights_h2_975 * hidden1_15 + weights_h2_976 * hidden1_16 + weights_h2_977 * hidden1_17 + weights_h2_978 * hidden1_18 + weights_h2_979 * hidden1_19 + weights_h2_980 * hidden1_20 + weights_h2_981 * hidden1_21 + weights_h2_982 * hidden1_22 + weights_h2_983 * hidden1_23 + weights_h2_984 * hidden1_24 + weights_h2_985 * hidden1_25 + weights_h2_986 * hidden1_26 + weights_h2_987 * hidden1_27 + weights_h2_988 * hidden1_28 + weights_h2_989 * hidden1_29 + weights_h2_990 * hidden1_30 + weights_h2_991 * hidden1_31 + bias_h2_30);
            hidden2_31 = $tanh(weights_h2_992 * hidden1_0 + weights_h2_993 * hidden1_1 + weights_h2_994 * hidden1_2 + weights_h2_995 * hidden1_3 + weights_h2_996 * hidden1_4 + weights_h2_997 * hidden1_5 + weights_h2_998 * hidden1_6 + weights_h2_999 * hidden1_7 + weights_h2_1000 * hidden1_8 + weights_h2_1001 * hidden1_9 + weights_h2_1002 * hidden1_10 + weights_h2_1003 * hidden1_11 + weights_h2_1004 * hidden1_12 + weights_h2_1005 * hidden1_13 + weights_h2_1006 * hidden1_14 + weights_h2_1007 * hidden1_15 + weights_h2_1008 * hidden1_16 + weights_h2_1009 * hidden1_17 + weights_h2_1010 * hidden1_18 + weights_h2_1011 * hidden1_19 + weights_h2_1012 * hidden1_20 + weights_h2_1013 * hidden1_21 + weights_h2_1014 * hidden1_22 + weights_h2_1015 * hidden1_23 + weights_h2_1016 * hidden1_24 + weights_h2_1017 * hidden1_25 + weights_h2_1018 * hidden1_26 + weights_h2_1019 * hidden1_27 + weights_h2_1020 * hidden1_28 + weights_h2_1021 * hidden1_29 + weights_h2_1022 * hidden1_30 + weights_h2_1023 * hidden1_31 + bias_h2_31);
            hidden2_32 = $tanh(weights_h2_1024 * hidden1_0 + weights_h2_1025 * hidden1_1 + weights_h2_1026 * hidden1_2 + weights_h2_1027 * hidden1_3 + weights_h2_1028 * hidden1_4 + weights_h2_1029 * hidden1_5 + weights_h2_1030 * hidden1_6 + weights_h2_1031 * hidden1_7 + weights_h2_1032 * hidden1_8 + weights_h2_1033 * hidden1_9 + weights_h2_1034 * hidden1_10 + weights_h2_1035 * hidden1_11 + weights_h2_1036 * hidden1_12 + weights_h2_1037 * hidden1_13 + weights_h2_1038 * hidden1_14 + weights_h2_1039 * hidden1_15 + weights_h2_1040 * hidden1_16 + weights_h2_1041 * hidden1_17 + weights_h2_1042 * hidden1_18 + weights_h2_1043 * hidden1_19 + weights_h2_1044 * hidden1_20 + weights_h2_1045 * hidden1_21 + weights_h2_1046 * hidden1_22 + weights_h2_1047 * hidden1_23 + weights_h2_1048 * hidden1_24 + weights_h2_1049 * hidden1_25 + weights_h2_1050 * hidden1_26 + weights_h2_1051 * hidden1_27 + weights_h2_1052 * hidden1_28 + weights_h2_1053 * hidden1_29 + weights_h2_1054 * hidden1_30 + weights_h2_1055 * hidden1_31 + bias_h2_32);
            hidden2_33 = $tanh(weights_h2_1056 * hidden1_0 + weights_h2_1057 * hidden1_1 + weights_h2_1058 * hidden1_2 + weights_h2_1059 * hidden1_3 + weights_h2_1060 * hidden1_4 + weights_h2_1061 * hidden1_5 + weights_h2_1062 * hidden1_6 + weights_h2_1063 * hidden1_7 + weights_h2_1064 * hidden1_8 + weights_h2_1065 * hidden1_9 + weights_h2_1066 * hidden1_10 + weights_h2_1067 * hidden1_11 + weights_h2_1068 * hidden1_12 + weights_h2_1069 * hidden1_13 + weights_h2_1070 * hidden1_14 + weights_h2_1071 * hidden1_15 + weights_h2_1072 * hidden1_16 + weights_h2_1073 * hidden1_17 + weights_h2_1074 * hidden1_18 + weights_h2_1075 * hidden1_19 + weights_h2_1076 * hidden1_20 + weights_h2_1077 * hidden1_21 + weights_h2_1078 * hidden1_22 + weights_h2_1079 * hidden1_23 + weights_h2_1080 * hidden1_24 + weights_h2_1081 * hidden1_25 + weights_h2_1082 * hidden1_26 + weights_h2_1083 * hidden1_27 + weights_h2_1084 * hidden1_28 + weights_h2_1085 * hidden1_29 + weights_h2_1086 * hidden1_30 + weights_h2_1087 * hidden1_31 + bias_h2_33);
            hidden2_34 = $tanh(weights_h2_1088 * hidden1_0 + weights_h2_1089 * hidden1_1 + weights_h2_1090 * hidden1_2 + weights_h2_1091 * hidden1_3 + weights_h2_1092 * hidden1_4 + weights_h2_1093 * hidden1_5 + weights_h2_1094 * hidden1_6 + weights_h2_1095 * hidden1_7 + weights_h2_1096 * hidden1_8 + weights_h2_1097 * hidden1_9 + weights_h2_1098 * hidden1_10 + weights_h2_1099 * hidden1_11 + weights_h2_1100 * hidden1_12 + weights_h2_1101 * hidden1_13 + weights_h2_1102 * hidden1_14 + weights_h2_1103 * hidden1_15 + weights_h2_1104 * hidden1_16 + weights_h2_1105 * hidden1_17 + weights_h2_1106 * hidden1_18 + weights_h2_1107 * hidden1_19 + weights_h2_1108 * hidden1_20 + weights_h2_1109 * hidden1_21 + weights_h2_1110 * hidden1_22 + weights_h2_1111 * hidden1_23 + weights_h2_1112 * hidden1_24 + weights_h2_1113 * hidden1_25 + weights_h2_1114 * hidden1_26 + weights_h2_1115 * hidden1_27 + weights_h2_1116 * hidden1_28 + weights_h2_1117 * hidden1_29 + weights_h2_1118 * hidden1_30 + weights_h2_1119 * hidden1_31 + bias_h2_34);
            hidden2_35 = $tanh(weights_h2_1120 * hidden1_0 + weights_h2_1121 * hidden1_1 + weights_h2_1122 * hidden1_2 + weights_h2_1123 * hidden1_3 + weights_h2_1124 * hidden1_4 + weights_h2_1125 * hidden1_5 + weights_h2_1126 * hidden1_6 + weights_h2_1127 * hidden1_7 + weights_h2_1128 * hidden1_8 + weights_h2_1129 * hidden1_9 + weights_h2_1130 * hidden1_10 + weights_h2_1131 * hidden1_11 + weights_h2_1132 * hidden1_12 + weights_h2_1133 * hidden1_13 + weights_h2_1134 * hidden1_14 + weights_h2_1135 * hidden1_15 + weights_h2_1136 * hidden1_16 + weights_h2_1137 * hidden1_17 + weights_h2_1138 * hidden1_18 + weights_h2_1139 * hidden1_19 + weights_h2_1140 * hidden1_20 + weights_h2_1141 * hidden1_21 + weights_h2_1142 * hidden1_22 + weights_h2_1143 * hidden1_23 + weights_h2_1144 * hidden1_24 + weights_h2_1145 * hidden1_25 + weights_h2_1146 * hidden1_26 + weights_h2_1147 * hidden1_27 + weights_h2_1148 * hidden1_28 + weights_h2_1149 * hidden1_29 + weights_h2_1150 * hidden1_30 + weights_h2_1151 * hidden1_31 + bias_h2_35);
            hidden2_36 = $tanh(weights_h2_1152 * hidden1_0 + weights_h2_1153 * hidden1_1 + weights_h2_1154 * hidden1_2 + weights_h2_1155 * hidden1_3 + weights_h2_1156 * hidden1_4 + weights_h2_1157 * hidden1_5 + weights_h2_1158 * hidden1_6 + weights_h2_1159 * hidden1_7 + weights_h2_1160 * hidden1_8 + weights_h2_1161 * hidden1_9 + weights_h2_1162 * hidden1_10 + weights_h2_1163 * hidden1_11 + weights_h2_1164 * hidden1_12 + weights_h2_1165 * hidden1_13 + weights_h2_1166 * hidden1_14 + weights_h2_1167 * hidden1_15 + weights_h2_1168 * hidden1_16 + weights_h2_1169 * hidden1_17 + weights_h2_1170 * hidden1_18 + weights_h2_1171 * hidden1_19 + weights_h2_1172 * hidden1_20 + weights_h2_1173 * hidden1_21 + weights_h2_1174 * hidden1_22 + weights_h2_1175 * hidden1_23 + weights_h2_1176 * hidden1_24 + weights_h2_1177 * hidden1_25 + weights_h2_1178 * hidden1_26 + weights_h2_1179 * hidden1_27 + weights_h2_1180 * hidden1_28 + weights_h2_1181 * hidden1_29 + weights_h2_1182 * hidden1_30 + weights_h2_1183 * hidden1_31 + bias_h2_36);
            hidden2_37 = $tanh(weights_h2_1184 * hidden1_0 + weights_h2_1185 * hidden1_1 + weights_h2_1186 * hidden1_2 + weights_h2_1187 * hidden1_3 + weights_h2_1188 * hidden1_4 + weights_h2_1189 * hidden1_5 + weights_h2_1190 * hidden1_6 + weights_h2_1191 * hidden1_7 + weights_h2_1192 * hidden1_8 + weights_h2_1193 * hidden1_9 + weights_h2_1194 * hidden1_10 + weights_h2_1195 * hidden1_11 + weights_h2_1196 * hidden1_12 + weights_h2_1197 * hidden1_13 + weights_h2_1198 * hidden1_14 + weights_h2_1199 * hidden1_15 + weights_h2_1200 * hidden1_16 + weights_h2_1201 * hidden1_17 + weights_h2_1202 * hidden1_18 + weights_h2_1203 * hidden1_19 + weights_h2_1204 * hidden1_20 + weights_h2_1205 * hidden1_21 + weights_h2_1206 * hidden1_22 + weights_h2_1207 * hidden1_23 + weights_h2_1208 * hidden1_24 + weights_h2_1209 * hidden1_25 + weights_h2_1210 * hidden1_26 + weights_h2_1211 * hidden1_27 + weights_h2_1212 * hidden1_28 + weights_h2_1213 * hidden1_29 + weights_h2_1214 * hidden1_30 + weights_h2_1215 * hidden1_31 + bias_h2_37);
            hidden2_38 = $tanh(weights_h2_1216 * hidden1_0 + weights_h2_1217 * hidden1_1 + weights_h2_1218 * hidden1_2 + weights_h2_1219 * hidden1_3 + weights_h2_1220 * hidden1_4 + weights_h2_1221 * hidden1_5 + weights_h2_1222 * hidden1_6 + weights_h2_1223 * hidden1_7 + weights_h2_1224 * hidden1_8 + weights_h2_1225 * hidden1_9 + weights_h2_1226 * hidden1_10 + weights_h2_1227 * hidden1_11 + weights_h2_1228 * hidden1_12 + weights_h2_1229 * hidden1_13 + weights_h2_1230 * hidden1_14 + weights_h2_1231 * hidden1_15 + weights_h2_1232 * hidden1_16 + weights_h2_1233 * hidden1_17 + weights_h2_1234 * hidden1_18 + weights_h2_1235 * hidden1_19 + weights_h2_1236 * hidden1_20 + weights_h2_1237 * hidden1_21 + weights_h2_1238 * hidden1_22 + weights_h2_1239 * hidden1_23 + weights_h2_1240 * hidden1_24 + weights_h2_1241 * hidden1_25 + weights_h2_1242 * hidden1_26 + weights_h2_1243 * hidden1_27 + weights_h2_1244 * hidden1_28 + weights_h2_1245 * hidden1_29 + weights_h2_1246 * hidden1_30 + weights_h2_1247 * hidden1_31 + bias_h2_38);
            hidden2_39 = $tanh(weights_h2_1248 * hidden1_0 + weights_h2_1249 * hidden1_1 + weights_h2_1250 * hidden1_2 + weights_h2_1251 * hidden1_3 + weights_h2_1252 * hidden1_4 + weights_h2_1253 * hidden1_5 + weights_h2_1254 * hidden1_6 + weights_h2_1255 * hidden1_7 + weights_h2_1256 * hidden1_8 + weights_h2_1257 * hidden1_9 + weights_h2_1258 * hidden1_10 + weights_h2_1259 * hidden1_11 + weights_h2_1260 * hidden1_12 + weights_h2_1261 * hidden1_13 + weights_h2_1262 * hidden1_14 + weights_h2_1263 * hidden1_15 + weights_h2_1264 * hidden1_16 + weights_h2_1265 * hidden1_17 + weights_h2_1266 * hidden1_18 + weights_h2_1267 * hidden1_19 + weights_h2_1268 * hidden1_20 + weights_h2_1269 * hidden1_21 + weights_h2_1270 * hidden1_22 + weights_h2_1271 * hidden1_23 + weights_h2_1272 * hidden1_24 + weights_h2_1273 * hidden1_25 + weights_h2_1274 * hidden1_26 + weights_h2_1275 * hidden1_27 + weights_h2_1276 * hidden1_28 + weights_h2_1277 * hidden1_29 + weights_h2_1278 * hidden1_30 + weights_h2_1279 * hidden1_31 + bias_h2_39);
            hidden2_40 = $tanh(weights_h2_1280 * hidden1_0 + weights_h2_1281 * hidden1_1 + weights_h2_1282 * hidden1_2 + weights_h2_1283 * hidden1_3 + weights_h2_1284 * hidden1_4 + weights_h2_1285 * hidden1_5 + weights_h2_1286 * hidden1_6 + weights_h2_1287 * hidden1_7 + weights_h2_1288 * hidden1_8 + weights_h2_1289 * hidden1_9 + weights_h2_1290 * hidden1_10 + weights_h2_1291 * hidden1_11 + weights_h2_1292 * hidden1_12 + weights_h2_1293 * hidden1_13 + weights_h2_1294 * hidden1_14 + weights_h2_1295 * hidden1_15 + weights_h2_1296 * hidden1_16 + weights_h2_1297 * hidden1_17 + weights_h2_1298 * hidden1_18 + weights_h2_1299 * hidden1_19 + weights_h2_1300 * hidden1_20 + weights_h2_1301 * hidden1_21 + weights_h2_1302 * hidden1_22 + weights_h2_1303 * hidden1_23 + weights_h2_1304 * hidden1_24 + weights_h2_1305 * hidden1_25 + weights_h2_1306 * hidden1_26 + weights_h2_1307 * hidden1_27 + weights_h2_1308 * hidden1_28 + weights_h2_1309 * hidden1_29 + weights_h2_1310 * hidden1_30 + weights_h2_1311 * hidden1_31 + bias_h2_40);
            hidden2_41 = $tanh(weights_h2_1312 * hidden1_0 + weights_h2_1313 * hidden1_1 + weights_h2_1314 * hidden1_2 + weights_h2_1315 * hidden1_3 + weights_h2_1316 * hidden1_4 + weights_h2_1317 * hidden1_5 + weights_h2_1318 * hidden1_6 + weights_h2_1319 * hidden1_7 + weights_h2_1320 * hidden1_8 + weights_h2_1321 * hidden1_9 + weights_h2_1322 * hidden1_10 + weights_h2_1323 * hidden1_11 + weights_h2_1324 * hidden1_12 + weights_h2_1325 * hidden1_13 + weights_h2_1326 * hidden1_14 + weights_h2_1327 * hidden1_15 + weights_h2_1328 * hidden1_16 + weights_h2_1329 * hidden1_17 + weights_h2_1330 * hidden1_18 + weights_h2_1331 * hidden1_19 + weights_h2_1332 * hidden1_20 + weights_h2_1333 * hidden1_21 + weights_h2_1334 * hidden1_22 + weights_h2_1335 * hidden1_23 + weights_h2_1336 * hidden1_24 + weights_h2_1337 * hidden1_25 + weights_h2_1338 * hidden1_26 + weights_h2_1339 * hidden1_27 + weights_h2_1340 * hidden1_28 + weights_h2_1341 * hidden1_29 + weights_h2_1342 * hidden1_30 + weights_h2_1343 * hidden1_31 + bias_h2_41);
            hidden2_42 = $tanh(weights_h2_1344 * hidden1_0 + weights_h2_1345 * hidden1_1 + weights_h2_1346 * hidden1_2 + weights_h2_1347 * hidden1_3 + weights_h2_1348 * hidden1_4 + weights_h2_1349 * hidden1_5 + weights_h2_1350 * hidden1_6 + weights_h2_1351 * hidden1_7 + weights_h2_1352 * hidden1_8 + weights_h2_1353 * hidden1_9 + weights_h2_1354 * hidden1_10 + weights_h2_1355 * hidden1_11 + weights_h2_1356 * hidden1_12 + weights_h2_1357 * hidden1_13 + weights_h2_1358 * hidden1_14 + weights_h2_1359 * hidden1_15 + weights_h2_1360 * hidden1_16 + weights_h2_1361 * hidden1_17 + weights_h2_1362 * hidden1_18 + weights_h2_1363 * hidden1_19 + weights_h2_1364 * hidden1_20 + weights_h2_1365 * hidden1_21 + weights_h2_1366 * hidden1_22 + weights_h2_1367 * hidden1_23 + weights_h2_1368 * hidden1_24 + weights_h2_1369 * hidden1_25 + weights_h2_1370 * hidden1_26 + weights_h2_1371 * hidden1_27 + weights_h2_1372 * hidden1_28 + weights_h2_1373 * hidden1_29 + weights_h2_1374 * hidden1_30 + weights_h2_1375 * hidden1_31 + bias_h2_42);
            hidden2_43 = $tanh(weights_h2_1376 * hidden1_0 + weights_h2_1377 * hidden1_1 + weights_h2_1378 * hidden1_2 + weights_h2_1379 * hidden1_3 + weights_h2_1380 * hidden1_4 + weights_h2_1381 * hidden1_5 + weights_h2_1382 * hidden1_6 + weights_h2_1383 * hidden1_7 + weights_h2_1384 * hidden1_8 + weights_h2_1385 * hidden1_9 + weights_h2_1386 * hidden1_10 + weights_h2_1387 * hidden1_11 + weights_h2_1388 * hidden1_12 + weights_h2_1389 * hidden1_13 + weights_h2_1390 * hidden1_14 + weights_h2_1391 * hidden1_15 + weights_h2_1392 * hidden1_16 + weights_h2_1393 * hidden1_17 + weights_h2_1394 * hidden1_18 + weights_h2_1395 * hidden1_19 + weights_h2_1396 * hidden1_20 + weights_h2_1397 * hidden1_21 + weights_h2_1398 * hidden1_22 + weights_h2_1399 * hidden1_23 + weights_h2_1400 * hidden1_24 + weights_h2_1401 * hidden1_25 + weights_h2_1402 * hidden1_26 + weights_h2_1403 * hidden1_27 + weights_h2_1404 * hidden1_28 + weights_h2_1405 * hidden1_29 + weights_h2_1406 * hidden1_30 + weights_h2_1407 * hidden1_31 + bias_h2_43);
            hidden2_44 = $tanh(weights_h2_1408 * hidden1_0 + weights_h2_1409 * hidden1_1 + weights_h2_1410 * hidden1_2 + weights_h2_1411 * hidden1_3 + weights_h2_1412 * hidden1_4 + weights_h2_1413 * hidden1_5 + weights_h2_1414 * hidden1_6 + weights_h2_1415 * hidden1_7 + weights_h2_1416 * hidden1_8 + weights_h2_1417 * hidden1_9 + weights_h2_1418 * hidden1_10 + weights_h2_1419 * hidden1_11 + weights_h2_1420 * hidden1_12 + weights_h2_1421 * hidden1_13 + weights_h2_1422 * hidden1_14 + weights_h2_1423 * hidden1_15 + weights_h2_1424 * hidden1_16 + weights_h2_1425 * hidden1_17 + weights_h2_1426 * hidden1_18 + weights_h2_1427 * hidden1_19 + weights_h2_1428 * hidden1_20 + weights_h2_1429 * hidden1_21 + weights_h2_1430 * hidden1_22 + weights_h2_1431 * hidden1_23 + weights_h2_1432 * hidden1_24 + weights_h2_1433 * hidden1_25 + weights_h2_1434 * hidden1_26 + weights_h2_1435 * hidden1_27 + weights_h2_1436 * hidden1_28 + weights_h2_1437 * hidden1_29 + weights_h2_1438 * hidden1_30 + weights_h2_1439 * hidden1_31 + bias_h2_44);
            hidden2_45 = $tanh(weights_h2_1440 * hidden1_0 + weights_h2_1441 * hidden1_1 + weights_h2_1442 * hidden1_2 + weights_h2_1443 * hidden1_3 + weights_h2_1444 * hidden1_4 + weights_h2_1445 * hidden1_5 + weights_h2_1446 * hidden1_6 + weights_h2_1447 * hidden1_7 + weights_h2_1448 * hidden1_8 + weights_h2_1449 * hidden1_9 + weights_h2_1450 * hidden1_10 + weights_h2_1451 * hidden1_11 + weights_h2_1452 * hidden1_12 + weights_h2_1453 * hidden1_13 + weights_h2_1454 * hidden1_14 + weights_h2_1455 * hidden1_15 + weights_h2_1456 * hidden1_16 + weights_h2_1457 * hidden1_17 + weights_h2_1458 * hidden1_18 + weights_h2_1459 * hidden1_19 + weights_h2_1460 * hidden1_20 + weights_h2_1461 * hidden1_21 + weights_h2_1462 * hidden1_22 + weights_h2_1463 * hidden1_23 + weights_h2_1464 * hidden1_24 + weights_h2_1465 * hidden1_25 + weights_h2_1466 * hidden1_26 + weights_h2_1467 * hidden1_27 + weights_h2_1468 * hidden1_28 + weights_h2_1469 * hidden1_29 + weights_h2_1470 * hidden1_30 + weights_h2_1471 * hidden1_31 + bias_h2_45);
            hidden2_46 = $tanh(weights_h2_1472 * hidden1_0 + weights_h2_1473 * hidden1_1 + weights_h2_1474 * hidden1_2 + weights_h2_1475 * hidden1_3 + weights_h2_1476 * hidden1_4 + weights_h2_1477 * hidden1_5 + weights_h2_1478 * hidden1_6 + weights_h2_1479 * hidden1_7 + weights_h2_1480 * hidden1_8 + weights_h2_1481 * hidden1_9 + weights_h2_1482 * hidden1_10 + weights_h2_1483 * hidden1_11 + weights_h2_1484 * hidden1_12 + weights_h2_1485 * hidden1_13 + weights_h2_1486 * hidden1_14 + weights_h2_1487 * hidden1_15 + weights_h2_1488 * hidden1_16 + weights_h2_1489 * hidden1_17 + weights_h2_1490 * hidden1_18 + weights_h2_1491 * hidden1_19 + weights_h2_1492 * hidden1_20 + weights_h2_1493 * hidden1_21 + weights_h2_1494 * hidden1_22 + weights_h2_1495 * hidden1_23 + weights_h2_1496 * hidden1_24 + weights_h2_1497 * hidden1_25 + weights_h2_1498 * hidden1_26 + weights_h2_1499 * hidden1_27 + weights_h2_1500 * hidden1_28 + weights_h2_1501 * hidden1_29 + weights_h2_1502 * hidden1_30 + weights_h2_1503 * hidden1_31 + bias_h2_46);
            hidden2_47 = $tanh(weights_h2_1504 * hidden1_0 + weights_h2_1505 * hidden1_1 + weights_h2_1506 * hidden1_2 + weights_h2_1507 * hidden1_3 + weights_h2_1508 * hidden1_4 + weights_h2_1509 * hidden1_5 + weights_h2_1510 * hidden1_6 + weights_h2_1511 * hidden1_7 + weights_h2_1512 * hidden1_8 + weights_h2_1513 * hidden1_9 + weights_h2_1514 * hidden1_10 + weights_h2_1515 * hidden1_11 + weights_h2_1516 * hidden1_12 + weights_h2_1517 * hidden1_13 + weights_h2_1518 * hidden1_14 + weights_h2_1519 * hidden1_15 + weights_h2_1520 * hidden1_16 + weights_h2_1521 * hidden1_17 + weights_h2_1522 * hidden1_18 + weights_h2_1523 * hidden1_19 + weights_h2_1524 * hidden1_20 + weights_h2_1525 * hidden1_21 + weights_h2_1526 * hidden1_22 + weights_h2_1527 * hidden1_23 + weights_h2_1528 * hidden1_24 + weights_h2_1529 * hidden1_25 + weights_h2_1530 * hidden1_26 + weights_h2_1531 * hidden1_27 + weights_h2_1532 * hidden1_28 + weights_h2_1533 * hidden1_29 + weights_h2_1534 * hidden1_30 + weights_h2_1535 * hidden1_31 + bias_h2_47);
            hidden2_48 = $tanh(weights_h2_1536 * hidden1_0 + weights_h2_1537 * hidden1_1 + weights_h2_1538 * hidden1_2 + weights_h2_1539 * hidden1_3 + weights_h2_1540 * hidden1_4 + weights_h2_1541 * hidden1_5 + weights_h2_1542 * hidden1_6 + weights_h2_1543 * hidden1_7 + weights_h2_1544 * hidden1_8 + weights_h2_1545 * hidden1_9 + weights_h2_1546 * hidden1_10 + weights_h2_1547 * hidden1_11 + weights_h2_1548 * hidden1_12 + weights_h2_1549 * hidden1_13 + weights_h2_1550 * hidden1_14 + weights_h2_1551 * hidden1_15 + weights_h2_1552 * hidden1_16 + weights_h2_1553 * hidden1_17 + weights_h2_1554 * hidden1_18 + weights_h2_1555 * hidden1_19 + weights_h2_1556 * hidden1_20 + weights_h2_1557 * hidden1_21 + weights_h2_1558 * hidden1_22 + weights_h2_1559 * hidden1_23 + weights_h2_1560 * hidden1_24 + weights_h2_1561 * hidden1_25 + weights_h2_1562 * hidden1_26 + weights_h2_1563 * hidden1_27 + weights_h2_1564 * hidden1_28 + weights_h2_1565 * hidden1_29 + weights_h2_1566 * hidden1_30 + weights_h2_1567 * hidden1_31 + bias_h2_48);
            hidden2_49 = $tanh(weights_h2_1568 * hidden1_0 + weights_h2_1569 * hidden1_1 + weights_h2_1570 * hidden1_2 + weights_h2_1571 * hidden1_3 + weights_h2_1572 * hidden1_4 + weights_h2_1573 * hidden1_5 + weights_h2_1574 * hidden1_6 + weights_h2_1575 * hidden1_7 + weights_h2_1576 * hidden1_8 + weights_h2_1577 * hidden1_9 + weights_h2_1578 * hidden1_10 + weights_h2_1579 * hidden1_11 + weights_h2_1580 * hidden1_12 + weights_h2_1581 * hidden1_13 + weights_h2_1582 * hidden1_14 + weights_h2_1583 * hidden1_15 + weights_h2_1584 * hidden1_16 + weights_h2_1585 * hidden1_17 + weights_h2_1586 * hidden1_18 + weights_h2_1587 * hidden1_19 + weights_h2_1588 * hidden1_20 + weights_h2_1589 * hidden1_21 + weights_h2_1590 * hidden1_22 + weights_h2_1591 * hidden1_23 + weights_h2_1592 * hidden1_24 + weights_h2_1593 * hidden1_25 + weights_h2_1594 * hidden1_26 + weights_h2_1595 * hidden1_27 + weights_h2_1596 * hidden1_28 + weights_h2_1597 * hidden1_29 + weights_h2_1598 * hidden1_30 + weights_h2_1599 * hidden1_31 + bias_h2_49);
            hidden2_50 = $tanh(weights_h2_1600 * hidden1_0 + weights_h2_1601 * hidden1_1 + weights_h2_1602 * hidden1_2 + weights_h2_1603 * hidden1_3 + weights_h2_1604 * hidden1_4 + weights_h2_1605 * hidden1_5 + weights_h2_1606 * hidden1_6 + weights_h2_1607 * hidden1_7 + weights_h2_1608 * hidden1_8 + weights_h2_1609 * hidden1_9 + weights_h2_1610 * hidden1_10 + weights_h2_1611 * hidden1_11 + weights_h2_1612 * hidden1_12 + weights_h2_1613 * hidden1_13 + weights_h2_1614 * hidden1_14 + weights_h2_1615 * hidden1_15 + weights_h2_1616 * hidden1_16 + weights_h2_1617 * hidden1_17 + weights_h2_1618 * hidden1_18 + weights_h2_1619 * hidden1_19 + weights_h2_1620 * hidden1_20 + weights_h2_1621 * hidden1_21 + weights_h2_1622 * hidden1_22 + weights_h2_1623 * hidden1_23 + weights_h2_1624 * hidden1_24 + weights_h2_1625 * hidden1_25 + weights_h2_1626 * hidden1_26 + weights_h2_1627 * hidden1_27 + weights_h2_1628 * hidden1_28 + weights_h2_1629 * hidden1_29 + weights_h2_1630 * hidden1_30 + weights_h2_1631 * hidden1_31 + bias_h2_50);
            hidden2_51 = $tanh(weights_h2_1632 * hidden1_0 + weights_h2_1633 * hidden1_1 + weights_h2_1634 * hidden1_2 + weights_h2_1635 * hidden1_3 + weights_h2_1636 * hidden1_4 + weights_h2_1637 * hidden1_5 + weights_h2_1638 * hidden1_6 + weights_h2_1639 * hidden1_7 + weights_h2_1640 * hidden1_8 + weights_h2_1641 * hidden1_9 + weights_h2_1642 * hidden1_10 + weights_h2_1643 * hidden1_11 + weights_h2_1644 * hidden1_12 + weights_h2_1645 * hidden1_13 + weights_h2_1646 * hidden1_14 + weights_h2_1647 * hidden1_15 + weights_h2_1648 * hidden1_16 + weights_h2_1649 * hidden1_17 + weights_h2_1650 * hidden1_18 + weights_h2_1651 * hidden1_19 + weights_h2_1652 * hidden1_20 + weights_h2_1653 * hidden1_21 + weights_h2_1654 * hidden1_22 + weights_h2_1655 * hidden1_23 + weights_h2_1656 * hidden1_24 + weights_h2_1657 * hidden1_25 + weights_h2_1658 * hidden1_26 + weights_h2_1659 * hidden1_27 + weights_h2_1660 * hidden1_28 + weights_h2_1661 * hidden1_29 + weights_h2_1662 * hidden1_30 + weights_h2_1663 * hidden1_31 + bias_h2_51);
            hidden2_52 = $tanh(weights_h2_1664 * hidden1_0 + weights_h2_1665 * hidden1_1 + weights_h2_1666 * hidden1_2 + weights_h2_1667 * hidden1_3 + weights_h2_1668 * hidden1_4 + weights_h2_1669 * hidden1_5 + weights_h2_1670 * hidden1_6 + weights_h2_1671 * hidden1_7 + weights_h2_1672 * hidden1_8 + weights_h2_1673 * hidden1_9 + weights_h2_1674 * hidden1_10 + weights_h2_1675 * hidden1_11 + weights_h2_1676 * hidden1_12 + weights_h2_1677 * hidden1_13 + weights_h2_1678 * hidden1_14 + weights_h2_1679 * hidden1_15 + weights_h2_1680 * hidden1_16 + weights_h2_1681 * hidden1_17 + weights_h2_1682 * hidden1_18 + weights_h2_1683 * hidden1_19 + weights_h2_1684 * hidden1_20 + weights_h2_1685 * hidden1_21 + weights_h2_1686 * hidden1_22 + weights_h2_1687 * hidden1_23 + weights_h2_1688 * hidden1_24 + weights_h2_1689 * hidden1_25 + weights_h2_1690 * hidden1_26 + weights_h2_1691 * hidden1_27 + weights_h2_1692 * hidden1_28 + weights_h2_1693 * hidden1_29 + weights_h2_1694 * hidden1_30 + weights_h2_1695 * hidden1_31 + bias_h2_52);
            hidden2_53 = $tanh(weights_h2_1696 * hidden1_0 + weights_h2_1697 * hidden1_1 + weights_h2_1698 * hidden1_2 + weights_h2_1699 * hidden1_3 + weights_h2_1700 * hidden1_4 + weights_h2_1701 * hidden1_5 + weights_h2_1702 * hidden1_6 + weights_h2_1703 * hidden1_7 + weights_h2_1704 * hidden1_8 + weights_h2_1705 * hidden1_9 + weights_h2_1706 * hidden1_10 + weights_h2_1707 * hidden1_11 + weights_h2_1708 * hidden1_12 + weights_h2_1709 * hidden1_13 + weights_h2_1710 * hidden1_14 + weights_h2_1711 * hidden1_15 + weights_h2_1712 * hidden1_16 + weights_h2_1713 * hidden1_17 + weights_h2_1714 * hidden1_18 + weights_h2_1715 * hidden1_19 + weights_h2_1716 * hidden1_20 + weights_h2_1717 * hidden1_21 + weights_h2_1718 * hidden1_22 + weights_h2_1719 * hidden1_23 + weights_h2_1720 * hidden1_24 + weights_h2_1721 * hidden1_25 + weights_h2_1722 * hidden1_26 + weights_h2_1723 * hidden1_27 + weights_h2_1724 * hidden1_28 + weights_h2_1725 * hidden1_29 + weights_h2_1726 * hidden1_30 + weights_h2_1727 * hidden1_31 + bias_h2_53);
            hidden2_54 = $tanh(weights_h2_1728 * hidden1_0 + weights_h2_1729 * hidden1_1 + weights_h2_1730 * hidden1_2 + weights_h2_1731 * hidden1_3 + weights_h2_1732 * hidden1_4 + weights_h2_1733 * hidden1_5 + weights_h2_1734 * hidden1_6 + weights_h2_1735 * hidden1_7 + weights_h2_1736 * hidden1_8 + weights_h2_1737 * hidden1_9 + weights_h2_1738 * hidden1_10 + weights_h2_1739 * hidden1_11 + weights_h2_1740 * hidden1_12 + weights_h2_1741 * hidden1_13 + weights_h2_1742 * hidden1_14 + weights_h2_1743 * hidden1_15 + weights_h2_1744 * hidden1_16 + weights_h2_1745 * hidden1_17 + weights_h2_1746 * hidden1_18 + weights_h2_1747 * hidden1_19 + weights_h2_1748 * hidden1_20 + weights_h2_1749 * hidden1_21 + weights_h2_1750 * hidden1_22 + weights_h2_1751 * hidden1_23 + weights_h2_1752 * hidden1_24 + weights_h2_1753 * hidden1_25 + weights_h2_1754 * hidden1_26 + weights_h2_1755 * hidden1_27 + weights_h2_1756 * hidden1_28 + weights_h2_1757 * hidden1_29 + weights_h2_1758 * hidden1_30 + weights_h2_1759 * hidden1_31 + bias_h2_54);
            hidden2_55 = $tanh(weights_h2_1760 * hidden1_0 + weights_h2_1761 * hidden1_1 + weights_h2_1762 * hidden1_2 + weights_h2_1763 * hidden1_3 + weights_h2_1764 * hidden1_4 + weights_h2_1765 * hidden1_5 + weights_h2_1766 * hidden1_6 + weights_h2_1767 * hidden1_7 + weights_h2_1768 * hidden1_8 + weights_h2_1769 * hidden1_9 + weights_h2_1770 * hidden1_10 + weights_h2_1771 * hidden1_11 + weights_h2_1772 * hidden1_12 + weights_h2_1773 * hidden1_13 + weights_h2_1774 * hidden1_14 + weights_h2_1775 * hidden1_15 + weights_h2_1776 * hidden1_16 + weights_h2_1777 * hidden1_17 + weights_h2_1778 * hidden1_18 + weights_h2_1779 * hidden1_19 + weights_h2_1780 * hidden1_20 + weights_h2_1781 * hidden1_21 + weights_h2_1782 * hidden1_22 + weights_h2_1783 * hidden1_23 + weights_h2_1784 * hidden1_24 + weights_h2_1785 * hidden1_25 + weights_h2_1786 * hidden1_26 + weights_h2_1787 * hidden1_27 + weights_h2_1788 * hidden1_28 + weights_h2_1789 * hidden1_29 + weights_h2_1790 * hidden1_30 + weights_h2_1791 * hidden1_31 + bias_h2_55);
            hidden2_56 = $tanh(weights_h2_1792 * hidden1_0 + weights_h2_1793 * hidden1_1 + weights_h2_1794 * hidden1_2 + weights_h2_1795 * hidden1_3 + weights_h2_1796 * hidden1_4 + weights_h2_1797 * hidden1_5 + weights_h2_1798 * hidden1_6 + weights_h2_1799 * hidden1_7 + weights_h2_1800 * hidden1_8 + weights_h2_1801 * hidden1_9 + weights_h2_1802 * hidden1_10 + weights_h2_1803 * hidden1_11 + weights_h2_1804 * hidden1_12 + weights_h2_1805 * hidden1_13 + weights_h2_1806 * hidden1_14 + weights_h2_1807 * hidden1_15 + weights_h2_1808 * hidden1_16 + weights_h2_1809 * hidden1_17 + weights_h2_1810 * hidden1_18 + weights_h2_1811 * hidden1_19 + weights_h2_1812 * hidden1_20 + weights_h2_1813 * hidden1_21 + weights_h2_1814 * hidden1_22 + weights_h2_1815 * hidden1_23 + weights_h2_1816 * hidden1_24 + weights_h2_1817 * hidden1_25 + weights_h2_1818 * hidden1_26 + weights_h2_1819 * hidden1_27 + weights_h2_1820 * hidden1_28 + weights_h2_1821 * hidden1_29 + weights_h2_1822 * hidden1_30 + weights_h2_1823 * hidden1_31 + bias_h2_56);
            hidden2_57 = $tanh(weights_h2_1824 * hidden1_0 + weights_h2_1825 * hidden1_1 + weights_h2_1826 * hidden1_2 + weights_h2_1827 * hidden1_3 + weights_h2_1828 * hidden1_4 + weights_h2_1829 * hidden1_5 + weights_h2_1830 * hidden1_6 + weights_h2_1831 * hidden1_7 + weights_h2_1832 * hidden1_8 + weights_h2_1833 * hidden1_9 + weights_h2_1834 * hidden1_10 + weights_h2_1835 * hidden1_11 + weights_h2_1836 * hidden1_12 + weights_h2_1837 * hidden1_13 + weights_h2_1838 * hidden1_14 + weights_h2_1839 * hidden1_15 + weights_h2_1840 * hidden1_16 + weights_h2_1841 * hidden1_17 + weights_h2_1842 * hidden1_18 + weights_h2_1843 * hidden1_19 + weights_h2_1844 * hidden1_20 + weights_h2_1845 * hidden1_21 + weights_h2_1846 * hidden1_22 + weights_h2_1847 * hidden1_23 + weights_h2_1848 * hidden1_24 + weights_h2_1849 * hidden1_25 + weights_h2_1850 * hidden1_26 + weights_h2_1851 * hidden1_27 + weights_h2_1852 * hidden1_28 + weights_h2_1853 * hidden1_29 + weights_h2_1854 * hidden1_30 + weights_h2_1855 * hidden1_31 + bias_h2_57);
            hidden2_58 = $tanh(weights_h2_1856 * hidden1_0 + weights_h2_1857 * hidden1_1 + weights_h2_1858 * hidden1_2 + weights_h2_1859 * hidden1_3 + weights_h2_1860 * hidden1_4 + weights_h2_1861 * hidden1_5 + weights_h2_1862 * hidden1_6 + weights_h2_1863 * hidden1_7 + weights_h2_1864 * hidden1_8 + weights_h2_1865 * hidden1_9 + weights_h2_1866 * hidden1_10 + weights_h2_1867 * hidden1_11 + weights_h2_1868 * hidden1_12 + weights_h2_1869 * hidden1_13 + weights_h2_1870 * hidden1_14 + weights_h2_1871 * hidden1_15 + weights_h2_1872 * hidden1_16 + weights_h2_1873 * hidden1_17 + weights_h2_1874 * hidden1_18 + weights_h2_1875 * hidden1_19 + weights_h2_1876 * hidden1_20 + weights_h2_1877 * hidden1_21 + weights_h2_1878 * hidden1_22 + weights_h2_1879 * hidden1_23 + weights_h2_1880 * hidden1_24 + weights_h2_1881 * hidden1_25 + weights_h2_1882 * hidden1_26 + weights_h2_1883 * hidden1_27 + weights_h2_1884 * hidden1_28 + weights_h2_1885 * hidden1_29 + weights_h2_1886 * hidden1_30 + weights_h2_1887 * hidden1_31 + bias_h2_58);
            hidden2_59 = $tanh(weights_h2_1888 * hidden1_0 + weights_h2_1889 * hidden1_1 + weights_h2_1890 * hidden1_2 + weights_h2_1891 * hidden1_3 + weights_h2_1892 * hidden1_4 + weights_h2_1893 * hidden1_5 + weights_h2_1894 * hidden1_6 + weights_h2_1895 * hidden1_7 + weights_h2_1896 * hidden1_8 + weights_h2_1897 * hidden1_9 + weights_h2_1898 * hidden1_10 + weights_h2_1899 * hidden1_11 + weights_h2_1900 * hidden1_12 + weights_h2_1901 * hidden1_13 + weights_h2_1902 * hidden1_14 + weights_h2_1903 * hidden1_15 + weights_h2_1904 * hidden1_16 + weights_h2_1905 * hidden1_17 + weights_h2_1906 * hidden1_18 + weights_h2_1907 * hidden1_19 + weights_h2_1908 * hidden1_20 + weights_h2_1909 * hidden1_21 + weights_h2_1910 * hidden1_22 + weights_h2_1911 * hidden1_23 + weights_h2_1912 * hidden1_24 + weights_h2_1913 * hidden1_25 + weights_h2_1914 * hidden1_26 + weights_h2_1915 * hidden1_27 + weights_h2_1916 * hidden1_28 + weights_h2_1917 * hidden1_29 + weights_h2_1918 * hidden1_30 + weights_h2_1919 * hidden1_31 + bias_h2_59);
            hidden2_60 = $tanh(weights_h2_1920 * hidden1_0 + weights_h2_1921 * hidden1_1 + weights_h2_1922 * hidden1_2 + weights_h2_1923 * hidden1_3 + weights_h2_1924 * hidden1_4 + weights_h2_1925 * hidden1_5 + weights_h2_1926 * hidden1_6 + weights_h2_1927 * hidden1_7 + weights_h2_1928 * hidden1_8 + weights_h2_1929 * hidden1_9 + weights_h2_1930 * hidden1_10 + weights_h2_1931 * hidden1_11 + weights_h2_1932 * hidden1_12 + weights_h2_1933 * hidden1_13 + weights_h2_1934 * hidden1_14 + weights_h2_1935 * hidden1_15 + weights_h2_1936 * hidden1_16 + weights_h2_1937 * hidden1_17 + weights_h2_1938 * hidden1_18 + weights_h2_1939 * hidden1_19 + weights_h2_1940 * hidden1_20 + weights_h2_1941 * hidden1_21 + weights_h2_1942 * hidden1_22 + weights_h2_1943 * hidden1_23 + weights_h2_1944 * hidden1_24 + weights_h2_1945 * hidden1_25 + weights_h2_1946 * hidden1_26 + weights_h2_1947 * hidden1_27 + weights_h2_1948 * hidden1_28 + weights_h2_1949 * hidden1_29 + weights_h2_1950 * hidden1_30 + weights_h2_1951 * hidden1_31 + bias_h2_60);
            hidden2_61 = $tanh(weights_h2_1952 * hidden1_0 + weights_h2_1953 * hidden1_1 + weights_h2_1954 * hidden1_2 + weights_h2_1955 * hidden1_3 + weights_h2_1956 * hidden1_4 + weights_h2_1957 * hidden1_5 + weights_h2_1958 * hidden1_6 + weights_h2_1959 * hidden1_7 + weights_h2_1960 * hidden1_8 + weights_h2_1961 * hidden1_9 + weights_h2_1962 * hidden1_10 + weights_h2_1963 * hidden1_11 + weights_h2_1964 * hidden1_12 + weights_h2_1965 * hidden1_13 + weights_h2_1966 * hidden1_14 + weights_h2_1967 * hidden1_15 + weights_h2_1968 * hidden1_16 + weights_h2_1969 * hidden1_17 + weights_h2_1970 * hidden1_18 + weights_h2_1971 * hidden1_19 + weights_h2_1972 * hidden1_20 + weights_h2_1973 * hidden1_21 + weights_h2_1974 * hidden1_22 + weights_h2_1975 * hidden1_23 + weights_h2_1976 * hidden1_24 + weights_h2_1977 * hidden1_25 + weights_h2_1978 * hidden1_26 + weights_h2_1979 * hidden1_27 + weights_h2_1980 * hidden1_28 + weights_h2_1981 * hidden1_29 + weights_h2_1982 * hidden1_30 + weights_h2_1983 * hidden1_31 + bias_h2_61);
            hidden2_62 = $tanh(weights_h2_1984 * hidden1_0 + weights_h2_1985 * hidden1_1 + weights_h2_1986 * hidden1_2 + weights_h2_1987 * hidden1_3 + weights_h2_1988 * hidden1_4 + weights_h2_1989 * hidden1_5 + weights_h2_1990 * hidden1_6 + weights_h2_1991 * hidden1_7 + weights_h2_1992 * hidden1_8 + weights_h2_1993 * hidden1_9 + weights_h2_1994 * hidden1_10 + weights_h2_1995 * hidden1_11 + weights_h2_1996 * hidden1_12 + weights_h2_1997 * hidden1_13 + weights_h2_1998 * hidden1_14 + weights_h2_1999 * hidden1_15 + weights_h2_2000 * hidden1_16 + weights_h2_2001 * hidden1_17 + weights_h2_2002 * hidden1_18 + weights_h2_2003 * hidden1_19 + weights_h2_2004 * hidden1_20 + weights_h2_2005 * hidden1_21 + weights_h2_2006 * hidden1_22 + weights_h2_2007 * hidden1_23 + weights_h2_2008 * hidden1_24 + weights_h2_2009 * hidden1_25 + weights_h2_2010 * hidden1_26 + weights_h2_2011 * hidden1_27 + weights_h2_2012 * hidden1_28 + weights_h2_2013 * hidden1_29 + weights_h2_2014 * hidden1_30 + weights_h2_2015 * hidden1_31 + bias_h2_62);
            hidden2_63 = $tanh(weights_h2_2016 * hidden1_0 + weights_h2_2017 * hidden1_1 + weights_h2_2018 * hidden1_2 + weights_h2_2019 * hidden1_3 + weights_h2_2020 * hidden1_4 + weights_h2_2021 * hidden1_5 + weights_h2_2022 * hidden1_6 + weights_h2_2023 * hidden1_7 + weights_h2_2024 * hidden1_8 + weights_h2_2025 * hidden1_9 + weights_h2_2026 * hidden1_10 + weights_h2_2027 * hidden1_11 + weights_h2_2028 * hidden1_12 + weights_h2_2029 * hidden1_13 + weights_h2_2030 * hidden1_14 + weights_h2_2031 * hidden1_15 + weights_h2_2032 * hidden1_16 + weights_h2_2033 * hidden1_17 + weights_h2_2034 * hidden1_18 + weights_h2_2035 * hidden1_19 + weights_h2_2036 * hidden1_20 + weights_h2_2037 * hidden1_21 + weights_h2_2038 * hidden1_22 + weights_h2_2039 * hidden1_23 + weights_h2_2040 * hidden1_24 + weights_h2_2041 * hidden1_25 + weights_h2_2042 * hidden1_26 + weights_h2_2043 * hidden1_27 + weights_h2_2044 * hidden1_28 + weights_h2_2045 * hidden1_29 + weights_h2_2046 * hidden1_30 + weights_h2_2047 * hidden1_31 + bias_h2_63);

            // Output layer (1 neuron)
            output_0 = weights_out_0 * hidden2_0 + weights_out_1 * hidden2_1 + weights_out_2 * hidden2_2 + weights_out_3 * hidden2_3 + weights_out_4 * hidden2_4 + weights_out_5 * hidden2_5 + weights_out_6 * hidden2_6 + weights_out_7 * hidden2_7 + weights_out_8 * hidden2_8 + weights_out_9 * hidden2_9 + weights_out_10 * hidden2_10 + weights_out_11 * hidden2_11 + weights_out_12 * hidden2_12 + weights_out_13 * hidden2_13 + weights_out_14 * hidden2_14 + weights_out_15 * hidden2_15 + weights_out_16 * hidden2_16 + weights_out_17 * hidden2_17 + weights_out_18 * hidden2_18 + weights_out_19 * hidden2_19 + weights_out_20 * hidden2_20 + weights_out_21 * hidden2_21 + weights_out_22 * hidden2_22 + weights_out_23 * hidden2_23 + weights_out_24 * hidden2_24 + weights_out_25 * hidden2_25 + weights_out_26 * hidden2_26 + weights_out_27 * hidden2_27 + weights_out_28 * hidden2_28 + weights_out_29 * hidden2_29 + weights_out_30 * hidden2_30 + weights_out_31 * hidden2_31 + weights_out_32 * hidden2_32 + weights_out_33 * hidden2_33 + weights_out_34 * hidden2_34 + weights_out_35 * hidden2_35 + weights_out_36 * hidden2_36 + weights_out_37 * hidden2_37 + weights_out_38 * hidden2_38 + weights_out_39 * hidden2_39 + weights_out_40 * hidden2_40 + weights_out_41 * hidden2_41 + weights_out_42 * hidden2_42 + weights_out_43 * hidden2_43 + weights_out_44 * hidden2_44 + weights_out_45 * hidden2_45 + weights_out_46 * hidden2_46 + weights_out_47 * hidden2_47 + weights_out_48 * hidden2_48 + weights_out_49 * hidden2_49 + weights_out_50 * hidden2_50 + weights_out_51 * hidden2_51 + weights_out_52 * hidden2_52 + weights_out_53 * hidden2_53 + weights_out_54 * hidden2_54 + weights_out_55 * hidden2_55 + weights_out_56 * hidden2_56 + weights_out_57 * hidden2_57 + weights_out_58 * hidden2_58 + weights_out_59 * hidden2_59 + weights_out_60 * hidden2_60 + weights_out_61 * hidden2_61 + weights_out_62 * hidden2_62 + weights_out_63 * hidden2_63 + bias_out_0;

            // Output denormalization
            Id_predicted = alpha * pow(vce + epsilon, beta) * pow(10, output_0);
            // Softly clip ic to [Ic_leak, Ic_max]
            ic_temp1 = Ic_leak + (Id_predicted - Ic_leak) / (1.0 + exp(-slope * (Id_predicted - Ic_leak)));
            ic_temp2 = Ic_max - (Ic_max - ic_temp1) / (1.0 + exp(-slope * (ic_temp1 - Ic_max)));
            ic = ic_temp2;
            I(a, c) <+ ic;

        end
    end
endmodule
